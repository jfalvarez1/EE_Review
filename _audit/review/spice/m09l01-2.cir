* LC Oscillators - m09l01-2
* from lessons/module-09/lesson-01.html (build table 2)
* EE_Review corpus. Node 'ground', 'gnd', 'agnd', 'dgnd' all map to 0.
* EE_Review solve-dc: solved
* EE_Review solve-op: skip: no semiconductors

L1 tank 0 10u
C1 tank 0 100p

.end
