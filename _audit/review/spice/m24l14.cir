* Debug Decision Trees and Test-Point Strategy - m24l14
* from lessons/module-24/lesson-14.html (build table 1)
* EE_Review corpus. Node 'ground', 'gnd', 'agnd', 'dgnd' all map to 0.
* EE_Review's own solvers skip this one: nonlinear or switched part: UAMP (Op-amp)
* EE_Review solve-dc: skip: nonlinear or switched part: UAMP (Op-amp)
* EE_Review solve-op: skip: nonlinear or switched part: UAMP (Op-amp)

VCC vcc 0 DC 5
VEE vee 0 DC -5
VIN inp 0 SIN(0 100m 1k) AC 100m
XUAMP inp fb out OPAMP
* fallback if X is unavailable: EUAMP out 0 inp fb 100k
R1 out fb 10k
R2 fb 0 1k

.end
