* BJT as a Voltage-Controlled Current Source - m05l01
* from lessons/module-05/lesson-01.html (build table 1)
* EE_Review corpus. Node 'ground', 'gnd', 'agnd', 'dgnd' all map to 0.
* EE_Review solve-dc: skip: nonlinear or switched part: Q1 (Transistor (BJT))
* EE_Review solve-op: solved
*
* MODEL 2N3904: Is=6.734e-15 BF=416.4 BR=0.7371 NF=1  (npn)

VBE base 0 DC 650m
VCE col 0 DC 5
Q1 col base 0 2N3904

.end
