* RF Filter Design - m21l05
* from lessons/module-21/lesson-05.html (build table 1)
* EE_Review corpus. Node 'ground', 'gnd', 'agnd', 'dgnd' all map to 0.
* EE_Review solve-dc: solved
* EE_Review solve-op: skip: no semiconductors

Vin in 0 SIN(0 1 100MEG) AC 1
Rs in node1 50
C1 node1 0 31.83p
L1 node1 node2 159.15n
C2 node2 0 31.83p
RL node2 0 50

.end
