* The Differential Pair - m05l11-5
* from lessons/module-05/lesson-11.html (build table 5)
* EE_Review corpus. Node 'ground', 'gnd', 'agnd', 'dgnd' all map to 0.
* EE_Review solve-dc: skip: nonlinear or switched part: Q1 (Transistor (BJT))
* EE_Review solve-op: skip: did not converge, even with gmin and source stepping
*
* MODEL 2N3904: Is=6.734e-15 BF=416.4 BR=0.7371 NF=1  (npn)
* MODEL 2N3906: Is=1.41e-15 BF=180.7 BR=4.977 NF=1  (pnp)

VCC vcc 0 DC 15
VEE 0 vee DC 15
VINP inp 0 AC 1m
Q1 c1 inm e12 2N3904
Q2 s2out inp e12 2N3904
Q3 c1 c1 vcc 2N3906
Q4 s2out c1 vcc 2N3906
ITAIL1 e12 vee DC 100u
Q5 s3in s2out vee 2N3904
R5 vcc s3in 10k
CC s2out s3in 30p
Q6 vcc s3in out 2N3904
Q7 vee s3in out 2N3906
RLOAD out 0 10k
RF inm out 10k
RI inp inm 10k

.end
