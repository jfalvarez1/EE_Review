* Comparators and Schmitt Triggers - m02l04
* from lessons/module-02/lesson-04.html (build table 1)
* EE_Review corpus. Node 'ground', 'gnd', 'agnd', 'dgnd' all map to 0.
* EE_Review's own solvers skip this one: nonlinear or switched part: XCOMP (Block (LM311))
* EE_Review solve-dc: skip: nonlinear or switched part: XCOMP (Block (LM311))
* EE_Review solve-op: skip: nonlinear or switched part: XCOMP (Block (LM311))
* UNSUPPORTED: XCOMP: subcircuit instance (Block (LM311))

XCOMP in ref out 0 LM311
R1 out ref 49k
R2 ref vref 1k
RPULL out vcc 4.7k
VCC vcc 0 DC 5
VREF vref 0 DC 2.5
VIN in 0 DC 2.5 SIN(2.5 1.5 100) AC 1.5

.end
