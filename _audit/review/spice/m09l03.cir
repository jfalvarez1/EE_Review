* Crystal Oscillators - m09l03
* from lessons/module-09/lesson-03.html (build table 1)
* EE_Review corpus. Node 'ground', 'gnd', 'agnd', 'dgnd' all map to 0.
* EE_Review's own solvers skip this one: nonlinear or switched part: X1 (Block (crystal))
* EE_Review solve-dc: skip: nonlinear or switched part: M1 (Transistor (MOSFET))
* EE_Review solve-op: skip: nonlinear or switched part: X1 (Block (crystal))
* UNSUPPORTED: X1: subcircuit instance (Block (crystal))
*
* MODEL NMOS: Vth=0.7 Kp=0.00011 WL=10 K=0.0011 lambda=0.04  (nmos)
* MODEL PMOS: Vth=0.7 Kp=0.00011 WL=10 K=0.0011 lambda=0.04  (pmos)

M1 out in vdd PMOS W=10u L=1u LAMBDA=0.04 VTO=0.7 KP=110u
M2 out in 0 NMOS W=10u L=1u LAMBDA=0.04 VTO=0.7 KP=110u
RF out in 1m
X1 in out CRYSTAL
C1 in 0 18p
C2 out 0 18p
VDD vdd 0 DC 3.3

.end
