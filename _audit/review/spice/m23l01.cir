* Multi-Rail Power Sequencing - m23l01
* from lessons/module-23/lesson-01.html (build table 1)
* EE_Review corpus. Node 'ground', 'gnd', 'agnd', 'dgnd' all map to 0.
* EE_Review's own solvers skip this one: time-varying source, no single DC value: VIN
* EE_Review solve-dc: skip: time-varying source, no single DC value: VIN
* EE_Review solve-op: skip: time-varying source, no single DC value: VIN
* UNSUPPORTED: Xcore: subcircuit instance (Block (regulator))
* UNSUPPORTED: Xaux: subcircuit instance (Block (regulator))
* UNSUPPORTED: Xio: subcircuit instance (Block (regulator))

VIN vin 0 PULSE(0 5 0 1n 1n 500m 1)
Xcore vin vin vcore REGULATOR
Xaux vin aux_en vaux REGULATOR
Xio vin io_en vio REGULATOR
R1 vcore aux_en 100k
C1 aux_en 0 100n
R2 vaux io_en 100k
C2 io_en 0 100n

.end
