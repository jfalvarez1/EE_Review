* Wireless Charging (Qi) Design - m25l10
* from lessons/module-25/lesson-10.html (build table 1)
* EE_Review corpus. Node 'ground', 'gnd', 'agnd', 'dgnd' all map to 0.
* EE_Review's own solvers skip this one: nonlinear or switched part: K1 (Magnetic coupling)
* EE_Review solve-dc: skip: nonlinear or switched part: K1 (Magnetic coupling)
* EE_Review solve-op: skip: nonlinear or switched part: K1 (Magnetic coupling)

Vtx vtx 0 SIN(0 12 125k) AC 12
Ctx vtx vtx_coil 130n
Ltx vtx_coil 0 12.5u
Lrx vrx_coil 0 10.4u
K1 Ltx Lrx 0.5
Crx vrx_coil vrx 156n
Rload vrx 0 10

.end
