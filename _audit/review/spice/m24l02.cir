* Overvoltage & Crowbar Protection - m24l02
* from lessons/module-24/lesson-02.html (build table 1)
* EE_Review corpus. Node 'ground', 'gnd', 'agnd', 'dgnd' all map to 0.
* EE_Review's own solvers skip this one: time-varying source, no single DC value: VPULSE
* EE_Review solve-dc: skip: time-varying source, no single DC value: VPULSE
* EE_Review solve-op: skip: time-varying source, no single DC value: VPULSE
* UNSUPPORTED: D_TVS: zener with no stated breakdown voltage (assumed BV = 5.1 V)
*
* MODEL ZENER: Is=1e-14 N=1 BV=5.1  (diode)

VPULSE in 0 PULSE(12 60 0 1u 1u 500u 1m)
RSOURCE in protected 10
D_TVS protected 0 ZENER
CLOAD protected 0 100p
RLOAD protected 0 1MEG

.end
