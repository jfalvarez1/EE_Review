* Overvoltage & Crowbar Protection - m24l02
* from lessons/module-24/lesson-02.html (build table 1)
* EE_Review corpus. Node 'ground', 'gnd', 'agnd', 'dgnd' all map to 0.
* EE_Review's own solvers skip this one: time-varying source, no single DC value: VPULSE
* EE_Review solve-dc: skip: time-varying source, no single DC value: VPULSE
* EE_Review solve-op: skip: time-varying source, no single DC value: VPULSE
* UNSUPPORTED: D_TVS: explicit zener BV=16.7 V, RZ=0.31 ohm requires a configured model; default ZENER is 5.1 V, 7 ohm

VPULSE in 0 PULSE(12 60 0 1u 1u 500u 1m)
RSOURCE in protected 10
* UNSUPPORTED: D_TVS: explicit zener BV=16.7 V, RZ=0.31 ohm requires a configured model; default ZENER is 5.1 V, 7 ohm; anode 0, cathode protected
CLOAD protected 0 100p
RLOAD protected 0 1MEG

.end
