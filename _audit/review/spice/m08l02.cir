* Bandgap Voltage References - m08l02
* from lessons/module-08/lesson-02.html (build table 1)
* EE_Review corpus. Node 'ground', 'gnd', 'agnd', 'dgnd' all map to 0.
* EE_Review solve-dc: skip: nonlinear or switched part: Q1 (Transistor (BJT))
* EE_Review solve-op: solved
*
* MODEL NPN: Is=1e-14 BF=100 BR=1 NF=1  (npn)

Q1 d1 d1 0 NPN
Q2 d2 d2 0 NPN
I1 vcc d1 DC 100u
I2 vcc d2 DC 10u
E1 vref d1 d1 d2 10.6
VCC vcc 0 DC 5

.end
