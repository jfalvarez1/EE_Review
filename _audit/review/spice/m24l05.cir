* Debugging Oscillation Problems - m24l05
* from lessons/module-24/lesson-05.html (build table 1)
* EE_Review corpus. Node 'ground', 'gnd', 'agnd', 'dgnd' all map to 0.
* EE_Review's own solvers skip this one: time-varying source, no single DC value: Vin
* EE_Review solve-dc: skip: time-varying source, no single DC value: Vin
* EE_Review solve-op: skip: time-varying source, no single DC value: Vin

Vin in 0 PULSE(0 100m 0 1n 1n 50u 100u) AC 1
XUamp 0 fb out OPAMP
* fallback if X is unavailable: EUamp out 0 0 fb 100k
Rin in fb 10k
Rf fb out 10k
Cload out 0 1n

.end
