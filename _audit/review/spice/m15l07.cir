* Pack Architecture: Series, Parallel and the C-Rate - m15l07
* from lessons/module-15/lesson-07.html (build table 1)
* EE_Review corpus. Node 'ground', 'gnd', 'agnd', 'dgnd' all map to 0.
* EE_Review solve-dc: solved
* EE_Review solve-op: skip: no semiconductors

Voc oc 0 DC 48.1
Rpack oc term 81.3m
Rwire term load 15m
Rload load 0 4.62
Cbulk load 0 2.2m

.end
