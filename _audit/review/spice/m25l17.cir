* Flyback Converter & Transformer Design - m25l17
* from lessons/module-25/lesson-17.html (build table 1)
* EE_Review corpus. Node 'ground', 'gnd', 'agnd', 'dgnd' all map to 0.
* EE_Review's own solvers skip this one: nonlinear or switched part: K1 (Magnetic coupling)
* EE_Review solve-dc: skip: nonlinear or switched part: Msw (Transistor (MOSFET))
* EE_Review solve-op: skip: nonlinear or switched part: K1 (Magnetic coupling)
*
* MODEL D1N4148: Is=2.52e-9 N=1.752  (diode)
* MODEL MBR1060: Is=0.0000317 N=1.37  (diode)
* MODEL NMOS: Vth=0.7 Kp=0.00011 WL=10 K=0.0011 lambda=0.04  (nmos)

Vin in 0 DC 48
Cin in 0 100u
L_lk in pri_a 2u
L_pri pri_a sw 200u
Msw sw pwm 0 NMOS W=10u L=1u LAMBDA=0.04 VTO=0.7 KP=110u
K1 L_pri L_sec 0.99
L_sec sec_a out_n 8u
D1 sec_a out_p MBR1060
Cout out_p out_n 470u
Rload out_p out_n 6
Vpwm pwm 0 PULSE(0 10 0 1n 1n 4.5u 10u)
D_clamp sw clamp_cap D1N4148
R_clamp clamp_cap in 10k
C_clamp clamp_cap in 10n

.end
