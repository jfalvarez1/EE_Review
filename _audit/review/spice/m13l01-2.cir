* Linear Regulators - m13l01-2
* from lessons/module-13/lesson-01.html (build table 2)
* EE_Review corpus. Node 'ground', 'gnd', 'agnd', 'dgnd' all map to 0.
* EE_Review solve-dc: skip: nonlinear or switched part: M1 (Transistor (MOSFET))
* EE_Review solve-op: skip: no unique operating point: an ideal op-amp around a nonlinear stage (a deadband admits a range of answers)
*
* MODEL PMOS: Vth=0.7 Kp=0.00011 WL=10 K=0.0011 lambda=0.04  (pmos)

VIN vin 0 DC 9
VREF ref 0 DC 1.25
XU1 ref fb gate OPAMP
* fallback if X is unavailable: EU1 gate 0 ref fb 100k
M1 vin gate vout PMOS W=10u L=1u LAMBDA=0.04 VTO=0.7 KP=110u
R1 vout fb 30k
R2 fb 0 10k
RLOAD vout 0 100

.end
