* Hot-Swap & Inrush Limiting - m24l03
* from lessons/module-24/lesson-03.html (build table 1)
* EE_Review corpus. Node 'ground', 'gnd', 'agnd', 'dgnd' all map to 0.
* EE_Review solve-dc: skip: nonlinear or switched part: M1 (Transistor (MOSFET))
* EE_Review solve-op: solved
*
* MODEL NMOS: Vth=0.7 Kp=0.00011 WL=10 K=0.0011 lambda=0.04  (nmos)

VIN in 0 DC 12
RSENSE in sense 10m
M1 sense gate out NMOS W=10u L=1u LAMBDA=0.04 VTO=0.7 KP=110u
COUT out 0 1m
RLOAD out 0 24

.end
