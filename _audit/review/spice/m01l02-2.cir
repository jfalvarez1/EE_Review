* Golden Rules and Basic Configurations - m01l02-2
* from lessons/module-01/lesson-02.html (build table 2)
* EE_Review corpus. Node 'ground', 'gnd', 'agnd', 'dgnd' all map to 0.
* EE_Review solve-dc: solved
* EE_Review solve-op: skip: no semiconductors

VCC vcc 0 DC 15
VEE vee 0 DC -15
VIN in 0 DC 1
XU1 in vminus out OPAMP
* fallback if X is unavailable: EU1 out 0 in vminus 100k
R1 vminus 0 1k
RF vminus out 3k

.end
