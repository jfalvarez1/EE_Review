* Speed vs Accuracy Trade-offs - m11l01
* from lessons/module-11/lesson-01.html (build table 1)
* EE_Review corpus. Node 'ground', 'gnd', 'agnd', 'dgnd' all map to 0.
* EE_Review's own solvers skip this one: time-varying source, no single DC value: VIN
* EE_Review solve-dc: skip: time-varying source, no single DC value: VIN
* EE_Review solve-op: skip: time-varying source, no single DC value: VIN

XU1 inP fb1 out1 OPAMP
* fallback if X is unavailable: EU1 out1 0 inP fb1 100k
R1 out1 fb1 9k
R2 fb1 0 1k
C1 out1 fb1 10p
XU2 inP fb2 out2 OPAMP
* fallback if X is unavailable: EU2 out2 0 inP fb2 100k
R3 out2 fb2 9k
R4 fb2 0 1k
VCC vcc 0 DC 5
VEE vee 0 DC -5
VIN inP 0 PULSE(0 100m 0 1n 1n 50u 100u)

.end
