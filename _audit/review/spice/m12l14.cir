* Power Supply Noise & PSRR - m12l14
* from lessons/module-12/lesson-14.html (build table 1)
* EE_Review corpus. Node 'ground', 'gnd', 'agnd', 'dgnd' all map to 0.
* EE_Review's own solvers skip this one: nonlinear or switched part: XU1 (Block (op-amp, PSRR modelled))
* EE_Review solve-dc: skip: nonlinear or switched part: XU1 (Block (op-amp, PSRR modelled))
* EE_Review solve-op: skip: nonlinear or switched part: XU1 (Block (op-amp, PSRR modelled))
* UNSUPPORTED: XU1: subcircuit instance (Block (op-amp, PSRR modelled))

VCC vcc 0 AC 1
CDEC vcc 0 10u
XU1 inp fb out vcc OP_AMP_PSRR_MODELLED
RF out fb 10k
RI fb 0 10k
VIN inp 0 DC 0

.end
