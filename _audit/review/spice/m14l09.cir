* Current Limiting Design - m14l09
* from lessons/module-14/lesson-09.html (build table 1)
* EE_Review corpus. Node 'ground', 'gnd', 'agnd', 'dgnd' all map to 0.
* EE_Review's own solvers skip this one: nonlinear or switched part: Xreg (Block (LDO with current limit))
* EE_Review solve-dc: skip: nonlinear or switched part: Xreg (Block (LDO with current limit))
* EE_Review solve-op: skip: nonlinear or switched part: Xreg (Block (LDO with current limit))
* UNSUPPORTED: Xreg: subcircuit instance (Block (LDO with current limit))

Vin in 0 DC 15
Xreg in out ilim LDO_WITH_CURRENT_LIMIT
Rilim ilim 0 10k
Cout out 0 100u
Rload out 0 2

.end
