* Transmission Lines and S-Parameters - m21l06
* from lessons/module-21/lesson-06.html (build table 1)
* EE_Review corpus. Node 'ground', 'gnd', 'agnd', 'dgnd' all map to 0.
* EE_Review solve-dc: solved
* EE_Review solve-op: skip: no semiconductors

Vsrc src 0 DC 1
Rsrc src n0 50
L1 n0 n1 2.9n
C1 n1 0 1.16p
L2 n1 n2 2.9n
C2 n2 0 1.16p
L3 n2 n3 2.9n
C3 n3 0 1.16p
L4 n3 n4 2.9n
C4 n4 0 1.16p
L5 n4 n5 2.9n
C5 n5 0 1.16p
Rload n5 0 100

.end
