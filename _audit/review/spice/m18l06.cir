* RTD and Thermocouple Interfaces - m18l06
* from lessons/module-18/lesson-06.html (build table 1)
* EE_Review corpus. Node 'ground', 'gnd', 'agnd', 'dgnd' all map to 0.
* EE_Review solve-dc: solved
* EE_Review solve-op: skip: no semiconductors

I_ex 0 rtd_force_p DC 1m
R_lead1 rtd_force_p rtd_p 2
R_lead2 rtd_n rtd_force_n 2
R_lead3 rtd_p sense_p 2
R_lead4 rtd_n sense_n 2
R_rtd rtd_p rtd_n 138.51
R_ref rtd_force_n 0 100
E_inamp out 0 sense_p sense_n 10

.end
