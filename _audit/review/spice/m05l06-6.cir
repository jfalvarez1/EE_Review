* Common-Emitter Amplifier - m05l06-6
* from lessons/module-05/lesson-06.html (build table 6)
* EE_Review corpus. Node 'ground', 'gnd', 'agnd', 'dgnd' all map to 0.
* EE_Review solve-dc: skip: nonlinear or switched part: Q1 (Transistor (BJT))
* EE_Review solve-op: solved
*
* MODEL 2N3904: Is=6.734e-15 BF=416.4 BR=0.7371 NF=1  (npn)

VCC vcc 0 DC 15
R1 vcc base 56k
R2 base 0 12k
RC vcc col 3.3k
RE emit 0 680
Q1 col base emit 2N3904

.end
