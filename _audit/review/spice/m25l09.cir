* Power-over-Ethernet (PoE) Design - m25l09
* from lessons/module-25/lesson-09.html (build table 1)
* EE_Review corpus. Node 'ground', 'gnd', 'agnd', 'dgnd' all map to 0.
* EE_Review solve-dc: skip: nonlinear or switched part: D1 (Diode)
* EE_Review solve-op: solved
*
* MODEL DIODE: Is=1e-14 N=1  (diode)

VPSE in 0 DC 5
D1 in vplus DIODE
D2 0 vplus DIODE
D3 vminus in DIODE
D4 vminus 0 DIODE
Rdet vplus vminus 25k

.end
