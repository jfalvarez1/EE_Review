* The Differential Pair - m05l11-2
* from lessons/module-05/lesson-11.html (build table 2)
* EE_Review corpus. Node 'ground', 'gnd', 'agnd', 'dgnd' all map to 0.
* EE_Review solve-dc: skip: nonlinear or switched part: Q1 (Transistor (BJT))
* EE_Review solve-op: solved
*
* MODEL 2N3904: Is=6.734e-15 BF=416.4 BR=0.7371 NF=1  (npn)

VCC vcc 0 DC 12
VIN in 0 SIN(0 5m 1k) AC 5m
R1 vcc b1 47k
R2 b1 0 4.7k
RC1 vcc c1 10k
RE1 e1 0 1k
Q1 c1 b1 e1 2N3904
CC1 c1 b2 1u
R3 vcc b2 47k
R4 b2 0 4.7k
RC2 vcc c2 10k
RE2 e2 0 1k
Q2 c2 b2 e2 2N3904
CIN in b1 1u

.end
