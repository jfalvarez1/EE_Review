* Audio Amplifier Fundamentals - m16l01
* from lessons/module-16/lesson-01.html (build table 1)
* EE_Review corpus. Node 'ground', 'gnd', 'agnd', 'dgnd' all map to 0.
* EE_Review solve-dc: solved
* EE_Review solve-op: skip: no semiconductors

XU1 in_ac fb out OPAMP
* fallback if X is unavailable: EU1 out 0 in_ac fb 100k
VCC vcc 0 DC 15
VEE vee 0 DC -15
CIN in in_ac 10u
RIN in_ac 0 470k
R1 out fb 20k
R2 fb 0 1k
VIN in 0 SIN(0 100m 1k) AC 100m
RLOAD out 0 10k

.end
