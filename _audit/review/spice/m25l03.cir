* USB-C Power Delivery System Design - m25l03
* from lessons/module-25/lesson-03.html (build table 1)
* EE_Review corpus. Node 'ground', 'gnd', 'agnd', 'dgnd' all map to 0.
* EE_Review solve-dc: solved
* EE_Review solve-op: skip: no semiconductors

Vcc vcc 0 DC 5
Rp vcc cc 22k
Rd cc 0 5.1k
Rp2 vcc cc2 10k
Rd2 cc2 0 5.1k

.end
