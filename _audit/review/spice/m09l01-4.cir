* LC Oscillators - m09l01-4
* from lessons/module-09/lesson-01.html (build table 4)
* EE_Review corpus. Node 'ground', 'gnd', 'agnd', 'dgnd' all map to 0.
* EE_Review solve-dc: solved
* EE_Review solve-op: skip: no semiconductors

L1 tank1 0 100u
C1 tank1 tank2 1n
R1 tank2 0 10

.end
