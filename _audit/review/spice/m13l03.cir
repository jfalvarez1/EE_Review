* Boost (Step-Up) Converter - m13l03
* from lessons/module-13/lesson-03.html (build table 1)
* EE_Review corpus. Node 'ground', 'gnd', 'agnd', 'dgnd' all map to 0.
* EE_Review's own solvers skip this one: nonlinear or switched part: M1 (Transistor (MOSFET, switching — low Rds(on)))
* EE_Review solve-dc: skip: nonlinear or switched part: M1 (Transistor (MOSFET, switching — low Rds(on)))
* EE_Review solve-op: skip: nonlinear or switched part: M1 (Transistor (MOSFET, switching — low Rds(on)))
*
* MODEL DIODE: Is=1e-14 N=1  (diode)
* MODEL NMOS: Vth=0.7 Kp=0.00011 WL=10 K=0.0011 lambda=0.04  (nmos)

VIN vin 0 DC 5
L1 vin sw 22u
M1 sw gate 0 NMOS W=10u L=1u LAMBDA=0.04 VTO=0.7 KP=110u
VGATE gate 0 PULSE(0 10 0 1n 1n 1.15u 2.3u)
D1 sw vout DIODE
COUT vout 0 100u
RLOAD vout 0 24

.end
