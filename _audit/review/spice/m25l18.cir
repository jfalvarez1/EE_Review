* Hot-Swap & Inrush Current Control - m25l18
* from lessons/module-25/lesson-18.html (build table 1)
* EE_Review corpus. Node 'ground', 'gnd', 'agnd', 'dgnd' all map to 0.
* EE_Review solve-dc: skip: nonlinear or switched part: M1 (Transistor (MOSFET))
* EE_Review solve-op: solved
*
* MODEL DIODE: Is=1e-14 N=1  (diode)
* MODEL NMOS: Vth=0.7 Kp=0.00011 WL=10 K=0.0011 lambda=0.04  (nmos)

Vbus bus 0 DC 12
Rsense bus sns 10m
M1 sns gate out NMOS W=10u L=1u LAMBDA=0.04 VTO=0.7 KP=110u
Igate 0 gate DC 10u
C_gate gate 0 10n
D_gate gate gate_max DIODE
V_gate_max gate_max 0 DC 10
E_sense sense_v 0 bus sns 1000
Cload out 0 1m
Rload out 0 10

.end
