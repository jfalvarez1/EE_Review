* Solar MPPT Charge Controller Design - m25l11
* from lessons/module-25/lesson-11.html (build table 1)
* EE_Review corpus. Node 'ground', 'gnd', 'agnd', 'dgnd' all map to 0.
* EE_Review's own solvers skip this one: time-varying source, no single DC value: Vctrl
* EE_Review solve-dc: skip: nonlinear or switched part: Dshunt (Diode)
* EE_Review solve-op: skip: time-varying source, no single DC value: Vctrl
* UNSUPPORTED: Ssw: subcircuit instance (Analog Switch)
*
* MODEL DIODE: Is=1e-14 N=1  (diode)

Iph 0 panel DC 5
Dshunt panel 0 DIODE
Vctrl ctrl 0 PULSE(0 1 0 1n 1n 6u 10u)
XSsw panel sw ctrl ANALOG_SWITCH
Lbuck sw out 100u
Dfree 0 sw DIODE
Cbat out 0 1m
Rbat out 0 5

.end
