* Protocol Debug Techniques - m20l10
* from lessons/module-20/lesson-10.html (build table 1)
* EE_Review corpus. Node 'ground', 'gnd', 'agnd', 'dgnd' all map to 0.
* EE_Review's own solvers skip this one: time-varying source, no single DC value: VSCL_DRV
* EE_Review solve-dc: skip: time-varying source, no single DC value: VSCL_DRV
* EE_Review solve-op: skip: time-varying source, no single DC value: VSCL_DRV
* UNSUPPORTED: X_SCL: subcircuit instance (Block (open-drain driver))
* UNSUPPORTED: X_SDA: subcircuit instance (Block (open-drain driver))

VCC vcc 0 DC 3.3
RP_SDA vcc sda 2.2k
RP_SCL vcc scl 2.2k
CBUS_SDA sda 0 100p
CBUS_SCL scl 0 50p
VSCL_DRV scl_drv 0 PULSE(3.3 0 0 1n 1n 625n 1.25u)
X_SCL scl_drv scl 0 OPEN_DRAIN_DRIVER
VSDA_DRV sda_drv 0 PULSE(3.3 0 0 1n 1n 1.25u 2.5u)
X_SDA sda_drv sda 0 OPEN_DRAIN_DRIVER

.end
