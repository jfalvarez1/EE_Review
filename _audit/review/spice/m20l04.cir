* Analog Signal Conditioning for ADCs - m20l04
* from lessons/module-20/lesson-04.html (build table 1)
* EE_Review corpus. Node 'ground', 'gnd', 'agnd', 'dgnd' all map to 0.
* EE_Review solve-dc: skip: nonlinear or switched part: D1 (Diode)
* EE_Review solve-op: skip: no unique operating point: an ideal op-amp around a nonlinear stage (a deadband admits a range of answers)
*
* MODEL SCHOTTKY: Is=0.0000317 N=1.37  (diode)

VIN input 0 SIN(0 50m 1k) AC 50m
XU1 input vmid amp_out OPAMP
* fallback if X is unavailable: EU1 amp_out 0 input vmid 100k
RF1 amp_out fb 32k
RG1 fb vmid 1k
VMID vmid 0 DC 1.65
R1 amp_out node1 1.59k
R2 node1 node2 1.59k
C1 node2 0 10n
C2 node1 filt_out 10n
XU2 node2 filt_out filt_out OPAMP
* fallback if X is unavailable: EU2 filt_out 0 node2 filt_out 100k
D1 filt_out vcc SCHOTTKY
D2 0 filt_out SCHOTTKY
VCC vcc 0 DC 3.3
VEE vee 0 DC 0

.end
