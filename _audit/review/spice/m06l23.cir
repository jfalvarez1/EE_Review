* MOSFET Applications - m06l23
* from lessons/module-06/lesson-23.html (build table 1)
* EE_Review corpus. Node 'ground', 'gnd', 'agnd', 'dgnd' all map to 0.
* EE_Review's own solvers skip this one: time-varying source, no single DC value: VGATE
* EE_Review solve-dc: skip: nonlinear or switched part: M1 (Transistor (MOSFET))
* EE_Review solve-op: skip: time-varying source, no single DC value: VGATE
*
* MODEL PMOS: Vth=0.7 Kp=0.00011 WL=10 K=0.0011 lambda=0.04  (pmos)

M1 drain gate vdd PMOS W=10u L=1u LAMBDA=0.04 VTO=0.7 KP=110u
VDD vdd 0 DC 12
RLOAD drain 0 6
VGATE gate 0 PULSE(12 0 0 1n 1n 2.5m 5m)

.end
