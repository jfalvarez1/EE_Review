* LED Driver Design - m25l07
* from lessons/module-25/lesson-07.html (build table 1)
* EE_Review corpus. Node 'ground', 'gnd', 'agnd', 'dgnd' all map to 0.
* EE_Review's own solvers skip this one: open-loop comparator: U1
* EE_Review solve-dc: skip: open-loop comparator: U1
* EE_Review solve-op: skip: open-loop comparator: U1
* UNSUPPORTED: FF1: subcircuit instance (SR Latch)
* UNSUPPORTED: Ssw: subcircuit instance (Analog Switch)
* UNSUPPORTED: DLED1: LED modelled as a silicon diode (Vf is wrong by over a volt)
* UNSUPPORTED: DLED2: LED modelled as a silicon diode (Vf is wrong by over a volt)
* UNSUPPORTED: DLED3: LED modelled as a silicon diode (Vf is wrong by over a volt)
*
* MODEL DIODE: Is=1e-14 N=1  (diode)
* MODEL SCHOTTKY: Is=0.0000317 N=1.37  (diode)

VIN vin 0 DC 24
Vth_hi ith_hi 0 DC 550m
Vth_lo ith_lo 0 DC 450m
XU1 led_cathode ith_hi rst OPAMP
* fallback if X is unavailable: EU1 rst 0 led_cathode ith_hi 100k
XU2 ith_lo led_cathode set OPAMP
* fallback if X is unavailable: EU2 set 0 ith_lo led_cathode 100k
XFF1 S set reset_rst pwm SR_LATCH
XSsw vin sw pwm ANALOG_SWITCH
L1 sw led_a 100u
D1 0 sw SCHOTTKY
DLED1 led_a led_b DIODE
DLED2 led_b led_c DIODE
DLED3 led_c led_cathode DIODE
Rsense led_cathode 0 286m

.end
