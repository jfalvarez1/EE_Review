* Buck-Boost Converter Design - m14l05
* from lessons/module-14/lesson-05.html (build table 1)
* EE_Review corpus. Node 'ground', 'gnd', 'agnd', 'dgnd' all map to 0.
* EE_Review's own solvers skip this one: nonlinear or switched part: M1 (Transistor (MOSFET, switching — low Rds(on)))
* EE_Review solve-dc: skip: nonlinear or switched part: M1 (Transistor (MOSFET, switching — low Rds(on)))
* EE_Review solve-op: skip: nonlinear or switched part: M1 (Transistor (MOSFET, switching — low Rds(on)))
* UNSUPPORTED: M1: subcircuit instance (Transistor (MOSFET, switching — low Rds(on)))
*
* MODEL SCHOTTKY: Is=0.0000317 N=1.37  (diode)

Vin in 0 DC 3.7
L1 in sw 10u
Cc sw l2_in 10u
L2 l2_in diode_a 10u
XM1 sw pwm 0 NMOS
Vpwm pwm 0 PULSE(0 5 0 940p 940p 470n 940n)
D1 diode_a out SCHOTTKY
D2 0 l2_in SCHOTTKY
Cout out 0 47u
Rload out 0 6.6

.end
