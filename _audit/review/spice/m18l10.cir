* MEMS Sensor Interfaces - m18l10
* from lessons/module-18/lesson-10.html (build table 1)
* EE_Review corpus. Node 'ground', 'gnd', 'agnd', 'dgnd' all map to 0.
* EE_Review solve-dc: solved
* EE_Review solve-op: skip: no semiconductors

VDD vdd 0 DC 5
V_mid vmid 0 DC 2.5
V_accel accel 0 DC 0
E_sense v_sense vmid accel 0 8
R_out v_sense out 1k
C_filter out 0 100n

.end
