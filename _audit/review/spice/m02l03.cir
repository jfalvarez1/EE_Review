* Active Filters - m02l03
* from lessons/module-02/lesson-03.html (build table 1)
* EE_Review corpus. Node 'ground', 'gnd', 'agnd', 'dgnd' all map to 0.
* EE_Review solve-dc: solved
* EE_Review solve-op: skip: no semiconductors

XU1 n2 out out OPAMP
* fallback if X is unavailable: EU1 out 0 n2 out 100k
R1 in n1 11.25k
R2 n1 n2 11.25k
C1 n1 out 20n
C2 n2 0 10n
VIN in 0 AC 1

.end
