* Complete Audio Subsystem Design - m25l01
* from lessons/module-25/lesson-01.html (build table 1)
* EE_Review corpus. Node 'ground', 'gnd', 'agnd', 'dgnd' all map to 0.
* EE_Review solve-dc: solved
* EE_Review solve-op: skip: no semiconductors

VDD VDD 0 DC 3.3
VIN IN 0 SIN(0 100m 1k) AC 100m
R_HP OUT 0 32
E_AMP OUT 0 IN 0 5

.end
