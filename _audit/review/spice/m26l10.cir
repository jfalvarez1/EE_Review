* Power Supply with Power Factor Correction - m26l10
* from lessons/module-26/lesson-10.html (build table 1)
* EE_Review corpus. Node 'ground', 'gnd', 'agnd', 'dgnd' all map to 0.
* EE_Review's own solvers skip this one: nonlinear or switched part: XPFC (Block (boost PFC stage))
* EE_Review solve-dc: skip: nonlinear or switched part: XPFC (Block (boost PFC stage))
* EE_Review solve-op: skip: nonlinear or switched part: XPFC (Block (boost PFC stage))
* UNSUPPORTED: XPFC: subcircuit instance (Block (boost PFC stage))
* UNSUPPORTED: XCTRL: subcircuit instance (Block (PFC controller))
* UNSUPPORTED: XLLC: subcircuit instance (Block (LLC resonant converter))

XPFC AC_RECT BUS IMON CTRL BOOST_PFC_STAGE
RSHUNT IMON 0 50m
XCTRL AC_RECT BUS IMON CTRL 0 PFC_CONTROLLER
VFCTRL FCTRL 0 DC 1.5
XLLC BUS OUT 0 FCTRL LLC_RESONANT_CONVERTER

.end
