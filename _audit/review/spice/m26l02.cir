* LED Backlight Driver Design - m26l02
* from lessons/module-26/lesson-02.html (build table 1)
* EE_Review corpus. Node 'ground', 'gnd', 'agnd', 'dgnd' all map to 0.
* EE_Review's own solvers skip this one: time-varying source, no single DC value: Vpwm
* EE_Review solve-dc: skip: nonlinear or switched part: Dboost (Diode)
* EE_Review solve-op: skip: time-varying source, no single DC value: Vpwm
*
* MODEL NMOS: Vth=0.7 Kp=0.00011 WL=10 K=0.0011 lambda=0.04  (nmos)
* MODEL SCHOTTKY: Is=0.0000317 N=1.37  (diode)

VIN vin 0 DC 12
Lboost vin sw 47u
Dboost sw vout SCHOTTKY
Vpwm pwm_gate 0 PULSE(0 10 0 1n 1n 6u 10u)
Msw sw pwm_gate 0 NMOS W=10u L=1u LAMBDA=0.04 VTO=0.7 KP=110u
Cout vout 0 10u
Vled1 vout led1_bot DC 9.6
Iled1 led1_bot 0 DC 350m
Vled2 vout led2_bot DC 9.6
Iled2 led2_bot 0 DC 350m
Vled3 vout led3_bot DC 9.6
Iled3 led3_bot 0 DC 350m
Vled4 vout led4_bot DC 9.6
Iled4 led4_bot 0 DC 350m

.end
