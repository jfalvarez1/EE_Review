* Peak Detectors - m08l07
* from lessons/module-08/lesson-07.html (build table 1)
* EE_Review corpus. Node 'ground', 'gnd', 'agnd', 'dgnd' all map to 0.
* EE_Review's own solvers skip this one: time-varying source, no single DC value: Vreset
* EE_Review solve-dc: skip: nonlinear or switched part: D1 (Diode)
* EE_Review solve-op: skip: time-varying source, no single DC value: Vreset
* UNSUPPORTED: Sreset: subcircuit instance (Analog Switch)
*
* MODEL 1N4148: Is=2.52e-9 N=1.752  (diode)

Vin in 0 SIN(0 2 1k) AC 2
XU1 in cap u1_out OPAMP
* fallback if X is unavailable: EU1 u1_out 0 in cap 100k
D1 u1_out cap 1N4148
D2 cap u1_out 1N4148
Chold cap 0 10n
XU2 cap buf_fb out OPAMP
* fallback if X is unavailable: EU2 out 0 cap buf_fb 100k
Rfb out buf_fb 1k
Rload out 0 1MEG
Vreset reset 0 PULSE(0 5 0 1n 1n 10u 5m)
XSreset cap 0 reset ANALOG_SWITCH

.end
