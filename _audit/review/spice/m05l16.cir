* BJT Amplifier Distortion - m05l16
* from lessons/module-05/lesson-16.html (build table 1)
* EE_Review corpus. Node 'ground', 'gnd', 'agnd', 'dgnd' all map to 0.
* EE_Review solve-dc: skip: nonlinear or switched part: Q1 (Transistor (BJT))
* EE_Review solve-op: solved
*
* MODEL 2N3904: Is=6.734e-15 BF=416.4 BR=0.7371 NF=1  (npn)

VCC vcc 0 DC 12
VIN in 0 SIN(0 10m 1k) AC 10m
R1 vcc base 47k
R2 base 0 7.5k
RC vcc col 4.7k
RE1 emitter emit2 100
RE2 emit2 0 820
CE emit2 0 100u
CIN in base 10u
Q1 col base emitter 2N3904

.end
