* Rail-to-Rail Output Stages - m07l03
* from lessons/module-07/lesson-03.html (build table 1)
* EE_Review corpus. Node 'ground', 'gnd', 'agnd', 'dgnd' all map to 0.
* EE_Review solve-dc: skip: nonlinear or switched part: M1 (Transistor (MOSFET))
* EE_Review solve-op: solved
*
* MODEL NMOS: Vth=0.7 Kp=0.00011 WL=10 K=0.0011 lambda=0.04  (nmos)
* MODEL PMOS: Vth=0.7 Kp=0.00011 WL=10 K=0.0011 lambda=0.04  (pmos)

M1 out gate vdd PMOS W=10u L=1u LAMBDA=0.04 VTO=0.7 KP=110u
M2 out gate 0 NMOS W=10u L=1u LAMBDA=0.04 VTO=0.7 KP=110u
VDD vdd 0 DC 3.3
VGATE gate 0 DC 1.65 SIN(1.65 1.5 1k) AC 1.5
RLOAD out 0 1k

.end
