* Reverse Polarity Protection - m24l01
* from lessons/module-24/lesson-01.html (build table 1)
* EE_Review corpus. Node 'ground', 'gnd', 'agnd', 'dgnd' all map to 0.
* EE_Review solve-dc: skip: nonlinear or switched part: M1 (Transistor (MOSFET))
* EE_Review solve-op: solved
*
* MODEL PMOS: Vth=0.7 Kp=0.00011 WL=10 K=0.0011 lambda=0.04  (pmos)
* MODEL ZENER: Is=1e-14 N=1 BV=5.1 RZ=7  (diode)

M1 vin gate vout PMOS W=10m L=1u LAMBDA=0.04 VTO=0.7 KP=110u
RGATE gate 0 10k
D1 gate vout ZENER
VIN vin 0 DC 12
RLOAD vout 0 12

.end
