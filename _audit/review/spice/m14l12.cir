* Design: Discharging a Rail to a Deadline - m14l12
* from lessons/module-14/lesson-12.html (build table 1)
* EE_Review corpus. Node 'ground', 'gnd', 'agnd', 'dgnd' all map to 0.
* EE_Review solve-dc: solved
* EE_Review solve-op: skip: no semiconductors

C1 rail 0 2.2m
R1 rail 0 12

.end
