* MOSFET Current Mirrors (Biasing in ICs) - m06l09
* from lessons/module-06/lesson-09.html (build table 1)
* EE_Review corpus. Node 'ground', 'gnd', 'agnd', 'dgnd' all map to 0.
* EE_Review solve-dc: skip: nonlinear or switched part: M1 (Transistor (MOSFET))
* EE_Review solve-op: solved
*
* MODEL NMOS: Vth=0.7 Kp=0.00011 WL=10 K=0.0011 lambda=0.04  (nmos)

VDD vdd 0 DC 5
IREF1 vdd nref1 DC 200u
M1 nref1 nref1 0 NMOS W=10u L=1u LAMBDA=0.04 VTO=0.7 KP=110u
M2 nout1 nref1 0 NMOS W=10u L=1u LAMBDA=0.04 VTO=0.7 KP=110u
RLOAD1 vdd nout1 20k
IREF2 vdd nref2 DC 200u
VBIAS vb 0 DC 1.8
M1C n1 n1 0 NMOS W=90u L=1u LAMBDA=0.04 VTO=0.7 KP=110u
M3C nref2 vb n1 NMOS W=90u L=1u LAMBDA=0.04 VTO=0.7 KP=110u
M2C n2 n1 0 NMOS W=90u L=1u LAMBDA=0.04 VTO=0.7 KP=110u
M4C nout2 vb n2 NMOS W=90u L=1u LAMBDA=0.04 VTO=0.7 KP=110u
RLOAD2 vdd nout2 20k

.end
