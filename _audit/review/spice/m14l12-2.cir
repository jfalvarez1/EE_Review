* Design: Discharging a Rail to a Deadline - m14l12-2
* from lessons/module-14/lesson-12.html (build table 2)
* EE_Review corpus. Node 'ground', 'gnd', 'agnd', 'dgnd' all map to 0.
* EE_Review's own solvers skip this one: time-varying source, no single DC value: VGATE
* EE_Review solve-dc: skip: nonlinear or switched part: M1 (N-channel MOSFET)
* EE_Review solve-op: skip: time-varying source, no single DC value: VGATE
*
* MODEL NMOS: Vth=0.7 Kp=0.00011 WL=10 K=0.0011 lambda=0.04  (nmos)

C1 rail 0 2.2m
R1 rail drain 12
M1 drain gate 0 NMOS W=10u L=1u LAMBDA=0.04 VTO=0.7 KP=110u
VGATE gate 0 PWL(0 0 10m 0 10.001m 3.3)

.end
