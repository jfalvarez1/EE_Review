* Hall Effect Sensors - m18l09
* from lessons/module-18/lesson-09.html (build table 1)
* EE_Review corpus. Node 'ground', 'gnd', 'agnd', 'dgnd' all map to 0.
* EE_Review solve-dc: solved
* EE_Review solve-op: skip: no semiconductors

V_supply vcc 0 DC 5
V_field b_field 0 DC 0
E_hall v_hall 0 b_field 0 0.1
V_quies vq 0 DC 2.5
E_out out vq v_hall 0 50
R_load out 0 10k

.end
