* The Differential Pair - m05l11-4
* from lessons/module-05/lesson-11.html (build table 4)
* EE_Review corpus. Node 'ground', 'gnd', 'agnd', 'dgnd' all map to 0.
* EE_Review solve-dc: skip: nonlinear or switched part: Q3 (Transistor (BJT))
* EE_Review solve-op: solved
*
* MODEL 2N3904: Is=6.734e-15 BF=416.4 BR=0.7371 NF=1  (npn)
* MODEL 2N3906: Is=1.41e-15 BF=180.7 BR=4.977 NF=1  (pnp)

VCC vcc 0 DC 6
VEE 0 vee DC 6
VINP inp 0 SIN(0 5m 1k) AC 5m
VINN inm 0 DC 0
Q3 c1 c1 vcc 2N3906
Q4 out c1 vcc 2N3906
Q1 c1 inp emit 2N3904
Q2 out inm emit 2N3904
ITAIL emit vee DC 1m

.end
