* Load Switches & Discharge Control - m23l02
* from lessons/module-23/lesson-02.html (build table 1)
* EE_Review corpus. Node 'ground', 'gnd', 'agnd', 'dgnd' all map to 0.
* EE_Review's own solvers skip this one: time-varying source, no single DC value: VEN
* EE_Review solve-dc: skip: time-varying source, no single DC value: VEN
* EE_Review solve-op: skip: time-varying source, no single DC value: VEN
*
* MODEL PMOS: Vth=0.7 Kp=0.00011 WL=10 K=0.0011 lambda=0.04  (pmos)

VIN vin 0 DC 3.3
VEN en 0 PULSE(0 3.3 0 1n 1n 4.5m 9m)
M1 vin gate vout PMOS W=10u L=1u LAMBDA=0.04 VTO=0.7 KP=110u
R_GATE en gate 10k
C_T gate 0 100n
COUT vout 0 100u
RLOAD vout 0 33

.end
