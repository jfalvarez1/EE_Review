* SPI Daisy Chaining - m20l08
* from lessons/module-20/lesson-08.html (build table 1)
* EE_Review corpus. Node 'ground', 'gnd', 'agnd', 'dgnd' all map to 0.
* EE_Review's own solvers skip this one: time-varying source, no single DC value: VCLK
* EE_Review solve-dc: skip: time-varying source, no single DC value: VCLK
* EE_Review solve-op: skip: time-varying source, no single DC value: VCLK
* UNSUPPORTED: X1: subcircuit instance (Block (shift register))
* UNSUPPORTED: X2: subcircuit instance (Block (shift register))
* UNSUPPORTED: X3: subcircuit instance (Block (shift register))
* UNSUPPORTED: X4: subcircuit instance (Block (shift register))

VCLK clk 0 PULSE(0 3.3 0 45p 45p 22.5n 45n)
VCS cs 0 PULSE(3.3 0 0 1n 1n 1.6u 3.2u)
VMOSI mosi 0 PULSE(0 3.3 0 95p 95p 47.5n 95n)
X1 mosi d1out clk cs vcc 0 SHIFT_REGISTER
X2 d1out d2out clk cs vcc 0 SHIFT_REGISTER
X3 d2out d3out clk cs vcc 0 SHIFT_REGISTER
X4 d3out miso clk cs vcc 0 SHIFT_REGISTER
VCC vcc 0 DC 3.3

.end
