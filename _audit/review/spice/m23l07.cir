* Case Study: Battery-Powered IoT Sensor Node - m23l07
* from lessons/module-23/lesson-07.html (build table 1)
* EE_Review corpus. Node 'ground', 'gnd', 'agnd', 'dgnd' all map to 0.
* EE_Review's own solvers skip this one: nonlinear or switched part: Xldo (Block (ultra-low-power LDO))
* EE_Review solve-dc: skip: nonlinear or switched part: Xldo (Block (ultra-low-power LDO))
* EE_Review solve-op: skip: nonlinear or switched part: Xldo (Block (ultra-low-power LDO))
* UNSUPPORTED: Xldo: subcircuit instance (Block (ultra-low-power LDO))

Vbat bat 0 DC 3.6
Xldo bat rail ULTRA_LOW_POWER_LDO
Imcu rail 0 PULSE(5u 5m 0 1n 1n 20m 2)
Isensor rail 0 DC 10u
Rsoc soc 0 1
Csoc soc 0 10.8k
EGsoc 0 soc rail 0 1

.end
