* Scenario: FPGA Power System Design - m18l05
* from lessons/module-18/lesson-05.html (build table 1)
* EE_Review corpus. Node 'ground', 'gnd', 'agnd', 'dgnd' all map to 0.
* EE_Review's own solvers skip this one: time-varying source, no single DC value: ILOAD
* EE_Review solve-dc: skip: time-varying source, no single DC value: ILOAD
* EE_Review solve-op: skip: time-varying source, no single DC value: ILOAD

VREG reg_out 0 DC 1
RREG reg_out pdn_in 5m
LPDN pdn_in pdn_mid 500p
RPDN pdn_mid vcore 2m
C_BULK vcore 0 470u
R_ESR_BULK vcore vcore_bulk 5m
L_ESL_BULK vcore_bulk 0 1n
C_MLCC vcore 0 100u
R_ESR_MLCC vcore vcore_mlcc 2m
L_ESL_MLCC vcore_mlcc 0 300p
C_HF vcore 0 10u
R_ESR_HF vcore vcore_hf 3m
L_ESL_HF vcore_hf 0 100p
ILOAD vcore 0 PULSE(0 10 0 1n 1n 50n 100n)

.end
