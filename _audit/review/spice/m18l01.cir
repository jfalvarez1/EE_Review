* Scenario: IoT Sensor Node Design - m18l01
* from lessons/module-18/lesson-01.html (build table 1)
* EE_Review corpus. Node 'ground', 'gnd', 'agnd', 'dgnd' all map to 0.
* EE_Review's own solvers skip this one: time-varying source, no single DC value: IACTIVE
* EE_Review solve-dc: skip: time-varying source, no single DC value: IACTIVE
* EE_Review solve-op: skip: time-varying source, no single DC value: IACTIVE

VBATT batt_int 0 DC 3
RBATT batt_int vbatt 5
ELDO vcc 0 vbatt 0 1
RLDO vcc 0 100MEG
ISLEEP vcc_sense 0 DC 1u
IACTIVE vcc_sense 0 PULSE(0 15m 0 1n 1n 5m 50m)
VSENSE vcc vcc_sense DC 0

.end
