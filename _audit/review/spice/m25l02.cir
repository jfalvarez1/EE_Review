* Complete Battery Management System (BMS) Design - m25l02
* from lessons/module-25/lesson-02.html (build table 1)
* EE_Review corpus. Node 'ground', 'gnd', 'agnd', 'dgnd' all map to 0.
* EE_Review solve-dc: solved
* EE_Review solve-op: skip: no semiconductors

V_chg CHG 0 DC 4.2
R_cc CHG BAT 1
R_esr BAT cell 100m
C_bat cell 0 1

.end
