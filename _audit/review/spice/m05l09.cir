* BJT as a Switch - m05l09
* from lessons/module-05/lesson-09.html (build table 1)
* EE_Review corpus. Node 'ground', 'gnd', 'agnd', 'dgnd' all map to 0.
* EE_Review's own solvers skip this one: time-varying source, no single DC value: VIN
* EE_Review solve-dc: skip: time-varying source, no single DC value: VIN
* EE_Review solve-op: skip: time-varying source, no single DC value: VIN
*
* MODEL 1N4148: Is=2.52e-9 N=1.752  (diode)
* MODEL 2N3904: Is=6.734e-15 BF=416.4 BR=0.7371 NF=1  (npn)

VCC 1 0 DC 12
VIN 5 0 PULSE(0 5 0 1n 1n 250u 500u)
RB 5 2 330
Q1 3 2 0 2N3904
L1 1 3a 100m
R_coil 3 3a 100
D1 3 1 1N4148

.end
