* Flyback and Isolated Topologies - m13l04
* from lessons/module-13/lesson-04.html (build table 1)
* EE_Review corpus. Node 'ground', 'gnd', 'agnd', 'dgnd' all map to 0.
* EE_Review's own solvers skip this one: nonlinear or switched part: K (Magnetic coupling)
* EE_Review solve-dc: skip: nonlinear or switched part: K (Magnetic coupling)
* EE_Review solve-op: skip: nonlinear or switched part: K (Magnetic coupling)
*
* MODEL DIODE: Is=1e-14 N=1  (diode)
* MODEL NMOS: Vth=0.7 Kp=0.00011 WL=10 K=0.0011 lambda=0.04  (nmos)

VIN vin 0 DC 170
L1 vin drain 500u
L2 0 sec_pre 5u
K L1 L2 0.98
D1 sec_pre vout DIODE
COUT vout 0 470u
RLOAD vout 0 4.8
M1 drain gate 0 NMOS W=10u L=1u LAMBDA=0.04 VTO=0.7 KP=110u
VGATE gate 0 PULSE(0 12 0 1n 1n 1.5u 3u)

.end
