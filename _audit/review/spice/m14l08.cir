* Soft Start Circuit Design - m14l08
* from lessons/module-14/lesson-08.html (build table 1)
* EE_Review corpus. Node 'ground', 'gnd', 'agnd', 'dgnd' all map to 0.
* EE_Review solve-dc: skip: nonlinear or switched part: Dclamp (Diode)
* EE_Review solve-op: solved
*
* MODEL 1N4148: Is=2.52e-9 N=1.752  (diode)
* MODEL SCHOTTKY: Is=0.0000317 N=1.37  (diode)

Iss 0 ss DC 10u
Css ss 0 100n
Dclamp ss ref 1N4148
Vref ref 0 DC 1.25
Eamp ctrl 0 ss 0 1
Eduty duty 0 ctrl 0 0.4
Esw sw 0 duty 0 12
L1 sw out 10u
D1 0 sw SCHOTTKY
Cout out 0 1m
Rload out 0 5

.end
