* BJT Frequency Response - m05l15
* from lessons/module-05/lesson-15.html (build table 1)
* EE_Review corpus. Node 'ground', 'gnd', 'agnd', 'dgnd' all map to 0.
* EE_Review solve-dc: skip: nonlinear or switched part: Q1 (Transistor (BJT))
* EE_Review solve-op: solved
*
* MODEL 2N3904: Is=6.734e-15 BF=416.4 BR=0.7371 NF=1  (npn)

VCC 1 0 DC 12
VIN src 0 AC 1
RS src 5 1k
R1 1 2 47k
R2 2 0 10k
Q1 3 2 4 2N3904
CPI 2 4 25p
CMU 2 3 4p
RC 1 3 2.2k
RE 4 0 1k
CE 4 0 10u
CIN 5 2 1u
COUT 3 6 1u
RL 6 0 10k

.end
