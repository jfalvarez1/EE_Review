* SPI Signal Integrity - m20l02
* from lessons/module-20/lesson-02.html (build table 1)
* EE_Review corpus. Node 'ground', 'gnd', 'agnd', 'dgnd' all map to 0.
* EE_Review's own solvers skip this one: nonlinear or switched part: T1 (Transmission Line)
* EE_Review solve-dc: skip: nonlinear or switched part: T1 (Transmission Line)
* EE_Review solve-op: skip: nonlinear or switched part: T1 (Transmission Line)
* UNSUPPORTED: XDRV: subcircuit instance (Block (line driver))

RTERM driver_out tline_in 33
T1 tline_in receiver_in 50 1n
CLOAD receiver_in 0 5p
XDRV clk_in driver_out vcc 0 LINE_DRIVER
VCLK clk_in 0 PULSE(0 3.3 0 20p 20p 10n 20n)
VCC vcc 0 DC 3.3

.end
