* Transimpedance Amplifiers (TIA) - m02l01
* from lessons/module-02/lesson-01.html (build table 1)
* EE_Review corpus. Node 'ground', 'gnd', 'agnd', 'dgnd' all map to 0.
* EE_Review solve-dc: solved
* EE_Review solve-op: skip: no semiconductors

XU1 0 vm out OPAMP
* fallback if X is unavailable: EU1 out 0 0 vm 100k
IPD 0 vm SIN(0 1u 10k) AC 1u
CPD vm 0 10p
RF vm out 1MEG
CF vm out 1p

.end
