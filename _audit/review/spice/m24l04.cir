* Power Supply Debugging - m24l04
* from lessons/module-24/lesson-04.html (build table 1)
* EE_Review corpus. Node 'ground', 'gnd', 'agnd', 'dgnd' all map to 0.
* EE_Review's own solvers skip this one: time-varying source, no single DC value: Vpwm
* EE_Review solve-dc: skip: time-varying source, no single DC value: Vpwm
* EE_Review solve-op: skip: time-varying source, no single DC value: Vpwm
* UNSUPPORTED: Ssw: subcircuit instance (Analog Switch)
*
* MODEL SCHOTTKY: Is=0.0000317 N=1.37  (diode)

Vin vin 0 DC 12
Rin_esr vin vin_cap 10m
Cin vin_cap 0 100u
Vpwm pwm 0 PULSE(0 1 0 400p 400p 160n 400n)
XSsw vin sw pwm ANALOG_SWITCH
D1 0 sw SCHOTTKY
L1 sw vout 10u
Rout_esr vout vout_cap 10m
Cout vout_cap 0 100u
Rload vout 0 2.5
Rfb1 vout fb 10k
Rfb2 fb 0 2k

.end
