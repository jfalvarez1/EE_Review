* Testing and Fixing Monotonicity Issues - m17l18
* from lessons/module-17/lesson-18.html (build table 1)
* EE_Review corpus. Node 'ground', 'gnd', 'agnd', 'dgnd' all map to 0.
* EE_Review solve-dc: solved
* EE_Review solve-op: skip: no semiconductors

VSET setpoint 0 DC 2.5
EAMP error 0 feedback setpoint 1
RINT error inv 100k
CINT inv ctrl 1u
XUINT 0 inv ctrl OPAMP
* fallback if X is unavailable: EUINT ctrl 0 0 inv 100k
EDAC dac_out 0 ctrl 0 1
RMOTOR dac_out position 100
CMOTOR position 0 100u
ESENS feedback 0 position 0 1

.end
