* Integrator and Differentiator - m01l03
* from lessons/module-01/lesson-03.html (build table 1)
* EE_Review corpus. Node 'ground', 'gnd', 'agnd', 'dgnd' all map to 0.
* EE_Review's own solvers skip this one: time-varying source, no single DC value: VIN1
* EE_Review solve-dc: skip: time-varying source, no single DC value: VIN1
* EE_Review solve-op: skip: time-varying source, no single DC value: VIN1
* UNSUPPORTED: VIN2: waveform has no SPICE form in this dialect: triangle 1 V amplitude at 1 kHz

XU1 0 int_m int_out OPAMP
* fallback if X is unavailable: EU1 int_out 0 0 int_m 100k
RIN in1 int_m 10k
CINT int_m int_out 100n
RF_DC int_m int_out 1MEG
VIN1 in1 0 PULSE(-1 1 0 1n 1n 250u 500u)
XU2 0 diff_m diff_out OPAMP
* fallback if X is unavailable: EU2 diff_out 0 0 diff_m 100k
CDIFF in2 n1 100n
RS n1 diff_m 100
RDIFF diff_m diff_out 10k
CF diff_m diff_out 1n
VIN2 in2 0 DC 1

.end
