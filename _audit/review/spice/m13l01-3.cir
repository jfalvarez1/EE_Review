* Linear Regulators - m13l01-3
* from lessons/module-13/lesson-01.html (build table 3)
* EE_Review corpus. Node 'ground', 'gnd', 'agnd', 'dgnd' all map to 0.
* EE_Review's own solvers skip this one: time-varying source, no single DC value: ILOAD
* EE_Review solve-dc: skip: time-varying source, no single DC value: ILOAD
* EE_Review solve-op: skip: time-varying source, no single DC value: ILOAD

COUT vout 0 10u
ILOAD vout 0 PULSE(50m 500m 0 1n 1n 25u 50u)

.end
