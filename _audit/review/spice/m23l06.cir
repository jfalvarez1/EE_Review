* Case Study: Medical ECG Amplifier - m23l06
* from lessons/module-23/lesson-06.html (build table 1)
* EE_Review corpus. Node 'ground', 'gnd', 'agnd', 'dgnd' all map to 0.
* EE_Review's own solvers skip this one: nonlinear or switched part: X1 (Block (instrumentation amplifier))
* EE_Review solve-dc: skip: nonlinear or switched part: X1 (Block (instrumentation amplifier))
* EE_Review solve-op: skip: nonlinear or switched part: X1 (Block (instrumentation amplifier))
* UNSUPPORTED: X1: subcircuit instance (Block (instrumentation amplifier))

Vecg_ inp 0 SIN(0 500u 1) AC 500u
Vecg_ inn 0 SIN(0 -500u 1) AC 500u
Vcm cm_src 0 SIN(0 1 60) AC 1
Rcouple cm_src cm 1MEG
E_add_p inp_cm inp cm 0 1
E_add_n inn_cm inn cm 0 1
Rp inp_cm inap 10k
Rn inn_cm inan 10k
X1 inap inan 0 out1 SUB_CIRCUIT_GAIN_1
Chp out1 hp1 3.2u
Rhp hp1 0 1MEG
Egain out2 0 hp1 0 100
Rlp out2 out 10k
Clp out 0 106n
Erld1 rld_a 0 inap 0 -0.5
Erld2 rld rld_a inan 0 -0.5
Rrld_out rld rl_electrode 10k
Rbody rl_electrode cm 50k

.end
