* Supervisory & Reset Circuits - m23l03
* from lessons/module-23/lesson-03.html (build table 1)
* EE_Review corpus. Node 'ground', 'gnd', 'agnd', 'dgnd' all map to 0.
* EE_Review's own solvers skip this one: time-varying source, no single DC value: VVCC
* EE_Review solve-dc: skip: time-varying source, no single DC value: VVCC
* EE_Review solve-op: skip: time-varying source, no single DC value: VVCC

VVCC vcc 0 PULSE(0 3.3 0 1n 1n 250m 500m)
Rdiv1 vcc fb 100k
Rdiv2 fb 0 100k
Vth vth 0 DC 1.24
XU1 fb vth comp OPAMP
* fallback if X is unavailable: EU1 comp 0 fb vth 100k
R_DLY comp reset_raw 100k
C_DLY reset_raw 0 1u
XU2 reset_raw vth reset OPAMP
* fallback if X is unavailable: EU2 reset 0 reset_raw vth 100k

.end
