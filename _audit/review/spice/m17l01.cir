* DAC Fundamentals - m17l01
* from lessons/module-17/lesson-01.html (build table 1)
* EE_Review corpus. Node 'ground', 'gnd', 'agnd', 'dgnd' all map to 0.
* EE_Review solve-dc: solved
* EE_Review solve-op: skip: no semiconductors

R0 b0 n0 20k
R0a n0 0 20k
R1 b1 n1 20k
R1a n1 n0 10k
R2 b2 n2 20k
R2a n2 n1 10k
R3 b3 n3 20k
R3a n3 n2 10k
RTERM n3 out 10k
VB3 b3 0 DC 5
VB2 b2 0 DC 0
VB1 b1 0 DC 5
VB0 b0 0 DC 0
XU1 out vout vout OPAMP
* fallback if X is unavailable: EU1 vout 0 out vout 100k
VCC vcc 0 DC 10
VEE vee 0 DC -10

.end
