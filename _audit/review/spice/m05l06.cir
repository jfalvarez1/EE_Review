* Common-Emitter Amplifier - m05l06
* from lessons/module-05/lesson-06.html (build table 1)
* EE_Review corpus. Node 'ground', 'gnd', 'agnd', 'dgnd' all map to 0.
* EE_Review solve-dc: skip: nonlinear or switched part: Q1 (Transistor (BJT))
* EE_Review solve-op: solved
*
* MODEL 2N3904: Is=6.734e-15 BF=416.4 BR=0.7371 NF=1  (npn)

VCC vcc 0 DC 12
VIN in 0 SIN(0 10m 1k) AC 10m
R1 vcc base 47k
R2 base 0 5.6k
Q1 col base emit 2N3904
RC vcc col 6k
RE emit 0 600
CIN in base 10u
COUT col out 10u
RLOAD out 0 10k

.end
