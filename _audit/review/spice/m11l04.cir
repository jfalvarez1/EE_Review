* System-Level Trade-offs - m11l04
* from lessons/module-11/lesson-04.html (build table 1)
* EE_Review corpus. Node 'ground', 'gnd', 'agnd', 'dgnd' all map to 0.
* EE_Review solve-dc: solved
* EE_Review solve-op: skip: no semiconductors

VSENSOR sensor 0 DC 10m
VNOISE1 sensor_n sensor AC 100u
XU1 sensor_n fb1 out1 OPAMP
* fallback if X is unavailable: EU1 out1 0 sensor_n fb1 100k
R1 out1 fb1 99k
R2 fb1 0 1k
VNOISE2 n2 out1 AC 10u
XU2 n2 fb2 out2 OPAMP
* fallback if X is unavailable: EU2 out2 0 n2 fb2 100k
R3 out2 fb2 10k
R4 fb2 0 10k
VCC vcc 0 DC 5
VEE vee 0 DC -5

.end
