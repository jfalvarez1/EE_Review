* MOSFET Fundamentals - m06l01
* from lessons/module-06/lesson-01.html (build table 1)
* EE_Review corpus. Node 'ground', 'gnd', 'agnd', 'dgnd' all map to 0.
* EE_Review solve-dc: skip: nonlinear or switched part: M1 (Transistor (MOSFET))
* EE_Review solve-op: solved
*
* MODEL NMOS: Vth=0.7 Kp=0.00011 WL=10 K=0.0011 lambda=0.04  (nmos)

M1 drain gate 0 NMOS W=10u L=1u LAMBDA=0.04 VTO=0.7 KP=110u
VGS gate 0 DC 5
VDS drain 0 DC 5

.end
