* Linear Regulators - m13l01
* from lessons/module-13/lesson-01.html (build table 1)
* EE_Review corpus. Node 'ground', 'gnd', 'agnd', 'dgnd' all map to 0.
* EE_Review's own solvers skip this one: nonlinear or switched part: XLDO (Block (LDO regulator))
* EE_Review solve-dc: skip: nonlinear or switched part: XLDO (Block (LDO regulator))
* EE_Review solve-op: skip: nonlinear or switched part: XLDO (Block (LDO regulator))
* UNSUPPORTED: XLDO: subcircuit instance (Block (LDO regulator))

XLDO vin vout 0 LDO_REGULATOR
VIN vin 0 DC 5
COUT vout 0 22u
ILOAD vout 0 PULSE(100m 500m 0 1n 1n 10u 20u)

.end
