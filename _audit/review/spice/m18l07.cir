* Strain Gauge Bridges - m18l07
* from lessons/module-18/lesson-07.html (build table 1)
* EE_Review corpus. Node 'ground', 'gnd', 'agnd', 'dgnd' all map to 0.
* EE_Review solve-dc: solved
* EE_Review solve-op: skip: no semiconductors

V_ex bridge_top 0 DC 5
R1 bridge_top vplus 350
R2 bridge_top vminus 350
R3 vplus 0 353.5
R4 vminus 0 350
E_inamp out 0 vplus vminus 100

.end
