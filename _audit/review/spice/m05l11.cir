* The Differential Pair - m05l11
* from lessons/module-05/lesson-11.html (build table 1)
* EE_Review corpus. Node 'ground', 'gnd', 'agnd', 'dgnd' all map to 0.
* EE_Review solve-dc: skip: nonlinear or switched part: Q1 (Transistor (BJT))
* EE_Review solve-op: solved
*
* MODEL 2N3904: Is=6.734e-15 BF=416.4 BR=0.7371 NF=1  (npn)

VCC vcc 0 DC 12
VEE 0 vee DC 12
VIN1 inp 0 AC 10m
VIN2 inm 0 DC 0
Q1 col1 inp emit 2N3904
Q2 col2 inm emit 2N3904
RC1 vcc col1 5k
RC2 vcc col2 5k
ITAIL emit vee DC 1m

.end
