* Ferrite Beads & EMI Filtering - m14l02
* from lessons/module-14/lesson-02.html (build table 1)
* EE_Review corpus. Node 'ground', 'gnd', 'agnd', 'dgnd' all map to 0.
* EE_Review solve-dc: solved
* EE_Review solve-op: skip: no semiconductors

VIN in 0 AC 100m
C1 in 0 1u
L_FB in_filt out_filt 1u
R_FB out_filt fb_out 50m
R_LOSS in_filt fb_out 120
C2 fb_out 0 10u
RLOAD fb_out 0 10

.end
