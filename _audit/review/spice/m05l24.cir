* Wideband BJT Amplifiers - m05l24
* from lessons/module-05/lesson-24.html (build table 1)
* EE_Review corpus. Node 'ground', 'gnd', 'agnd', 'dgnd' all map to 0.
* EE_Review solve-dc: skip: nonlinear or switched part: Q1 (Transistor (BJT))
* EE_Review solve-op: solved
*
* MODEL 2N3904: Is=6.734e-15 BF=416.4 BR=0.7371 NF=1  (npn)

VCC vcc 0 DC 12
VIN in 0 AC 1
R1 vcc base 47k
R2 base 0 10k
RC vcc col 1k
LP col col2 4.1u
Q1 col2 base emitter 2N3904
RE emitter 0 330
CIN in base 1u
COUT col2 out 1u
CL out 0 10p

.end
