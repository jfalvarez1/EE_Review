* Buck (Step-Down) Converter - m13l02
* from lessons/module-13/lesson-02.html (build table 1)
* EE_Review corpus. Node 'ground', 'gnd', 'agnd', 'dgnd' all map to 0.
* EE_Review's own solvers skip this one: nonlinear or switched part: M1 (Transistor (MOSFET, switching — low Rds(on)))
* EE_Review solve-dc: skip: nonlinear or switched part: M1 (Transistor (MOSFET, switching — low Rds(on)))
* EE_Review solve-op: skip: nonlinear or switched part: M1 (Transistor (MOSFET, switching — low Rds(on)))
*
* MODEL NMOS: Vth=0.7 Kp=0.00011 WL=10 K=0.0011 lambda=0.04  (nmos)

M1 vin gate_h sw NMOS W=10u L=1u LAMBDA=0.04 VTO=0.7 KP=110u
M2 sw gate_l 0 NMOS W=10u L=1u LAMBDA=0.04 VTO=0.7 KP=110u
VGATE_H gate_h 0 PULSE(0 12 0 833p 833p 416.5n 833n)
VGATE_L gate_l 0 PULSE(12 0 0 833p 833p 416.5n 833n)
VIN vin 0 DC 12
L1 sw vout 10u
COUT vout 0 100u
RLOAD vout 0 5

.end
