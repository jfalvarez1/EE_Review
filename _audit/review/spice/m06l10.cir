* CMOS Inverter Fundamentals - m06l10
* from lessons/module-06/lesson-10.html (build table 1)
* EE_Review corpus. Node 'ground', 'gnd', 'agnd', 'dgnd' all map to 0.
* EE_Review solve-dc: skip: nonlinear or switched part: MP (Transistor (MOSFET))
* EE_Review solve-op: solved
*
* MODEL NMOS: Vth=0.7 Kp=0.00011 WL=10 K=0.0011 lambda=0.04  (nmos)
* MODEL PMOS: Vth=0.7 Kp=0.00011 WL=10 K=0.0011 lambda=0.04  (pmos)

VDD vdd 0 DC 3.3
VIN in 0 DC 0
MP out in vdd PMOS W=10u L=1u LAMBDA=0.04 VTO=0.7 KP=110u
MN out in 0 NMOS W=10u L=1u LAMBDA=0.04 VTO=0.7 KP=110u
CL out 0 20f

.end
