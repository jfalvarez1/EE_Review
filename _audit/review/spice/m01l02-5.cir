* Golden Rules and Basic Configurations - m01l02-5
* from lessons/module-01/lesson-02.html (build table 5)
* EE_Review corpus. Node 'ground', 'gnd', 'agnd', 'dgnd' all map to 0.
* EE_Review solve-dc: solved
* EE_Review solve-op: skip: no semiconductors

VCC vcc 0 DC 12
VEE vee 0 DC -12
V1 in1 0 DC 1
V2 in2 0 DC 2
XU1 0 sum out OPAMP
* fallback if X is unavailable: EU1 out 0 0 sum 100k
R1 in1 sum 10k
R2 in2 sum 10k
RF sum out 10k

.end
