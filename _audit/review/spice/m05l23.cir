* Emitter Follower Oscillation - m05l23
* from lessons/module-05/lesson-23.html (build table 1)
* EE_Review corpus. Node 'ground', 'gnd', 'agnd', 'dgnd' all map to 0.
* EE_Review's own solvers skip this one: time-varying source, no single DC value: VIN
* EE_Review solve-dc: skip: time-varying source, no single DC value: VIN
* EE_Review solve-op: skip: time-varying source, no single DC value: VIN
*
* MODEL 2N3904: Is=6.734e-15 BF=416.4 BR=0.7371 NF=1  (npn)

VCC vcc 0 DC 12
VIN in 0 PULSE(0 1 0 1000p 1000p 500n 1u) AC 1
RS in base1 1k
RB_STOP base1 base 47
Q1 vcc base emitter 2N3904
RE emitter 0 1k
ROUT emitter out 10
CL out 0 100p

.end
