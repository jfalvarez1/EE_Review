* DNL, INL, and Missing Codes - m17l16
* from lessons/module-17/lesson-16.html (build table 1)
* EE_Review corpus. Node 'ground', 'gnd', 'agnd', 'dgnd' all map to 0.
* EE_Review solve-dc: solved
* EE_Review solve-op: skip: no semiconductors

VREF vref 0 DC 2.5
R1 vref t3 1k
R2 t3 t2 1k
R3 t2 t1 1.5k
R4 t1 0 1k
E1 buf 0 t2 0 1

.end
