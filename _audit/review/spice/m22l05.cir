* Conducted Emissions - m22l05
* from lessons/module-22/lesson-05.html (build table 1)
* EE_Review corpus. Node 'ground', 'gnd', 'agnd', 'dgnd' all map to 0.
* EE_Review's own solvers skip this one: nonlinear or switched part: K1 (Magnetic coupling)
* EE_Review solve-dc: skip: nonlinear or switched part: K1 (Magnetic coupling)
* EE_Review solve-op: skip: nonlinear or switched part: K1 (Magnetic coupling)

Vnoise IN 0 AC 1
Cx1 IN 0 100n
L1 IN N1 10m
L2 0 N2 10m
K1 L1 L2 0.99
Cy1 N1 earth 2.2n
Cy2 N2 earth 2.2n
Rg earth 0 100m
Lleak N1 N3 100u
Cx2 N3 N2 100n
Rload N3 N2 50
Rlisn IN 0 50

.end
