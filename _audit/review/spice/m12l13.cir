* Op-Amp Stability & Compensation - m12l13
* from lessons/module-12/lesson-13.html (build table 1)
* EE_Review corpus. Node 'ground', 'gnd', 'agnd', 'dgnd' all map to 0.
* EE_Review solve-dc: solved
* EE_Review solve-op: skip: no semiconductors

VIN inp 0 AC 1
XUAMP inp fb out OPAMP
* fallback if X is unavailable: EUAMP out 0 inp fb 100k
RF out fb 9k
RI fb 0 1k
CLOAD out 0 100p

.end
