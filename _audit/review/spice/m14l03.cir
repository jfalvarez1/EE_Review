* Grounding Strategy for Mixed-Signal - m14l03
* from lessons/module-14/lesson-03.html (build table 1)
* EE_Review corpus. Node 'ground', 'gnd', 'agnd', 'dgnd' all map to 0.
* EE_Review solve-dc: solved
* EE_Review solve-op: skip: no semiconductors

L_SOLID gnd_a gnd_b 500p
R_SOLID gnd_b gnd_ref 1m
L_SPLIT_A split_a split_mid 5n
R_SPLIT split_mid split_b 10m
L_SPLIT_B split_b gnd_ref 5n
ISOLID gnd_a 0 AC 1
ISPLIT split_a 0 AC 1
VREF gnd_ref 0 DC 0

.end
