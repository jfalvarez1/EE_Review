* Gate Drive Design (Q g , R g , Miller) - m06l13
* from lessons/module-06/lesson-13.html (build table 1)
* EE_Review corpus. Node 'ground', 'gnd', 'agnd', 'dgnd' all map to 0.
* EE_Review's own solvers skip this one: time-varying source, no single DC value: VDRV
* EE_Review solve-dc: skip: time-varying source, no single DC value: VDRV
* EE_Review solve-op: skip: time-varying source, no single DC value: VDRV
*
* MODEL NMOS: Vth=0.7 Kp=0.00011 WL=10 K=0.0011 lambda=0.04  (nmos)

VDD vdd 0 DC 12
VDRV drv 0 PULSE(0 10 0 200p 200p 100n 200n)
RG drv gate 5
RL vdd drain 10
M1 drain gate 0 NMOS W=10u L=1u LAMBDA=0.04 VTO=0.7 KP=110u

.end
