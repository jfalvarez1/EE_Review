* Mixers and Frequency Conversion - m21l04
* from lessons/module-21/lesson-04.html (build table 1)
* EE_Review corpus. Node 'ground', 'gnd', 'agnd', 'dgnd' all map to 0.
* EE_Review's own solvers skip this one: nonlinear or switched part: M1 (Transistor (MOSFET, switching — low Rds(on)))
* EE_Review solve-dc: skip: nonlinear or switched part: M1 (Transistor (MOSFET, switching — low Rds(on)))
* EE_Review solve-op: skip: nonlinear or switched part: M1 (Transistor (MOSFET, switching — low Rds(on)))
*
* MODEL NMOS: Vth=0.7 Kp=0.00011 WL=10 K=0.0011 lambda=0.04  (nmos)

VDD vdd 0 DC 1.8
Ibias tail 0 DC 2m
Vrf_p rfp 0 SIN(0 10m 2.4G) AC 10m
Vrf_n rfn 0 SIN(0 10m 2.4G) AC 10m
Vlo_p lop 0 SIN(0 300m 2.3G) AC 300m
Vlo_n lon 0 SIN(0 300m 2.3G) AC 300m
M1 sw1 rfp tail NMOS W=10u L=1u LAMBDA=0.04 VTO=0.7 KP=110u
M2 sw2 rfn tail NMOS W=10u L=1u LAMBDA=0.04 VTO=0.7 KP=110u
M3 ifn lop sw1 NMOS W=10u L=1u LAMBDA=0.04 VTO=0.7 KP=110u
M4 ifp lon sw1 NMOS W=10u L=1u LAMBDA=0.04 VTO=0.7 KP=110u
M5 ifp lop sw2 NMOS W=10u L=1u LAMBDA=0.04 VTO=0.7 KP=110u
M6 ifn lon sw2 NMOS W=10u L=1u LAMBDA=0.04 VTO=0.7 KP=110u
RL1 vdd ifp 500
RL2 vdd ifn 500
Cout_p ifp if_out_p 10p
Cout_n ifn if_out_n 10p
RL_out if_out_p if_out_n 100

.end
