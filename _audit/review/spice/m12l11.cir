* BJT Operating Regions & Practical Effects - m12l11
* from lessons/module-12/lesson-11.html (build table 1)
* EE_Review corpus. Node 'ground', 'gnd', 'agnd', 'dgnd' all map to 0.
* EE_Review solve-dc: skip: nonlinear or switched part: Q1 (Transistor (BJT))
* EE_Review solve-op: solved
*
* MODEL Q2N2222: Is=1.4e-14 BF=200 BR=3 NF=1  (npn)

VCC vcc 0 DC 12
VIN vin 0 DC 0
RB vin base 100k
Q1 coll base 0 Q2N2222
RC vcc coll 1k

.end
