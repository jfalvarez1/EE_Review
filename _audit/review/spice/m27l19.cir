* Measuring Safely: CAT Ratings and Seeing This Without Touching Mains - m27l19
* from lessons/module-27/lesson-19.html (build table 1)
* EE_Review corpus. Node 'ground', 'gnd', 'agnd', 'dgnd' all map to 0.
* EE_Review solve-dc: solved
* EE_Review solve-op: skip: no semiconductors

Vac line 0 DC 170
Rsense line a 100m
Rload a b 10
Lload b 0 26.5m
Cpfc a 0 120u

.end
