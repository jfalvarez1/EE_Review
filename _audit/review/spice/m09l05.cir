* Schmitt Triggers & Hysteresis - m09l05
* from lessons/module-09/lesson-05.html (build table 1)
* EE_Review corpus. Node 'ground', 'gnd', 'agnd', 'dgnd' all map to 0.
* EE_Review solve-dc: solved
* EE_Review solve-op: skip: no semiconductors

XU1 fb in2 out OPAMP
* fallback if X is unavailable: EU1 out 0 fb in2 100k
R1 out fb 40k
R2 fb vref 10k
VREF vref 0 DC 2.5
VIN in 0 DC 2.5 SIN(2.5 1.5 1k) AC 1.5
VNOISE noise 0 SIN(0 100m 50k) AC 100m
E1 in2 in noise 0 1
VCC vcc 0 DC 5
VEE vee 0 DC 0

.end
