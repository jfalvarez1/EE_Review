* Power Supply Filtering - m14l07
* from lessons/module-14/lesson-07.html (build table 1)
* EE_Review corpus. Node 'ground', 'gnd', 'agnd', 'dgnd' all map to 0.
* EE_Review's own solvers skip this one: time-varying source, no single DC value: Vsw
* EE_Review solve-dc: skip: time-varying source, no single DC value: Vsw
* EE_Review solve-op: skip: time-varying source, no single DC value: Vsw

Vsw in 0 PULSE(4.9 5.1 0 1000p 1000p 500n 1u)
L1 in out 10u
Rl in out 20m
C1 out cap_esr 100u
Resr cap_esr 0 50m
Rload out 0 5
Vac in 0 AC 1

.end
