* The Differential Pair - m05l11-3
* from lessons/module-05/lesson-11.html (build table 3)
* EE_Review corpus. Node 'ground', 'gnd', 'agnd', 'dgnd' all map to 0.
* EE_Review solve-dc: skip: nonlinear or switched part: Q1 (Transistor (BJT))
* EE_Review solve-op: solved
*
* MODEL 2N3904: Is=6.734e-15 BF=416.4 BR=0.7371 NF=1  (npn)

VCC vcc 0 DC 12
VIN in 0 SIN(0 10m 1k) AC 10m
R1 vcc b1 47k
R2 b1 0 47k
Q1 vcc b1 e1 2N3904
RE1 e1 0 10k
Q2 c2 e1 e2 2N3904
RC2 vcc c2 10k
RE2 e2 0 1k
CIN in b1 1u

.end
