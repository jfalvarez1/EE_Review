* MOSFET Parasitics & Gate Drive - m12l12
* from lessons/module-12/lesson-12.html (build table 1)
* EE_Review corpus. Node 'ground', 'gnd', 'agnd', 'dgnd' all map to 0.
* EE_Review's own solvers skip this one: time-varying source, no single DC value: VDRV
* EE_Review solve-dc: skip: time-varying source, no single DC value: VDRV
* EE_Review solve-op: skip: time-varying source, no single DC value: VDRV
*
* MODEL NMOS: Vth=0.7 Kp=0.00011 WL=10 K=0.0011 lambda=0.04  (nmos)

VDD drain 0 DC 48
VDRV drv 0 PULSE(0 10 0 1000p 1000p 500n 1u)
RG drv gate 10
RLOAD drain vdd_load 10
LLOAD vdd_load vdd 10n
M1 drain gate source NMOS W=10u L=1u LAMBDA=0.04 VTO=0.7 KP=110u
LSOURCE source 0 2n

.end
