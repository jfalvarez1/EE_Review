* Converter Architecture & Monotonicity - m17l17
* from lessons/module-17/lesson-17.html (build table 1)
* EE_Review corpus. Node 'ground', 'gnd', 'agnd', 'dgnd' all map to 0.
* EE_Review's own solvers skip this one: nonlinear or switched part: S3 (SPDT Switch)
* EE_Review solve-dc: skip: nonlinear or switched part: S3 (SPDT Switch)
* EE_Review solve-op: skip: nonlinear or switched part: S3 (SPDT Switch)
* UNSUPPORTED: S3: subcircuit instance (SPDT Switch)
* UNSUPPORTED: S2: subcircuit instance (SPDT Switch)
* UNSUPPORTED: S1: subcircuit instance (SPDT Switch)
* UNSUPPORTED: S0: subcircuit instance (SPDT Switch)

VREF vref 0 DC 2.5
VIN vin 0 DC 1.25
Vb3 b3_ctrl 0 DC 5
Vb2 b2_ctrl 0 DC 0
Vb1 b1_ctrl 0 DC 0
Vb0 b0_ctrl 0 DC 0
XS3 vref 0 n3 b3_ctrl SPDT_SWITCH
XS2 vref 0 n2 b2_ctrl SPDT_SWITCH
XS1 vref 0 n1 b1_ctrl SPDT_SWITCH
XS0 vref 0 n0 b0_ctrl SPDT_SWITCH
C3 n3 vcm 8.08p
C2 n2 vcm 4p
C1 n1 vcm 2p
C0 n0 vcm 1p
CT vcm 0 1p
XUCMP vcm vin cmp OPAMP
* fallback if X is unavailable: EUCMP cmp 0 vcm vin 100k

.end
