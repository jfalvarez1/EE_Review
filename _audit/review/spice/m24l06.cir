* Debugging Ground Loop Issues - m24l06
* from lessons/module-24/lesson-06.html (build table 1)
* EE_Review corpus. Node 'ground', 'gnd', 'agnd', 'dgnd' all map to 0.
* EE_Review solve-dc: skip: singular - no unique operating point (an amplifier with no feedback, or a floating section)
* EE_Review solve-op: skip: no semiconductors

Vsig sig 0 SIN(0 1 1k) AC 1
Rin sig amp_in 10k
XUamp amp_in gnd_local out OPAMP
* fallback if X is unavailable: EUamp out 0 amp_in gnd_local 100k
Rgnd gnd_local 0 100m
Inoise 0 gnd_local SIN(0 100m 60) AC 100m
Rload out 0 10k

.end
