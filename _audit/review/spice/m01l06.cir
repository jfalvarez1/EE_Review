* Power Supply Rejection Ratio (PSRR) - m01l06
* from lessons/module-01/lesson-06.html (build table 1)
* EE_Review corpus. Node 'ground', 'gnd', 'agnd', 'dgnd' all map to 0.
* EE_Review solve-dc: solved
* EE_Review solve-op: skip: no semiconductors

VSMPS smps 0 AC 1
RF smps vsup 10
CF vsup 0 100u

.end
