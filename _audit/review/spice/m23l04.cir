* Case Study: Industrial 4-20mA Sensor Interface - m23l04
* from lessons/module-23/lesson-04.html (build table 1)
* EE_Review corpus. Node 'ground', 'gnd', 'agnd', 'dgnd' all map to 0.
* EE_Review solve-dc: skip: nonlinear or switched part: D1 (Diode)
* EE_Review solve-op: skip: did not converge, even with gmin and source stepping
* UNSUPPORTED: D1: zener with no stated breakdown voltage (assumed BV = 5.1 V)
* UNSUPPORTED: D2: zener with no stated breakdown voltage (assumed BV = 5.1 V)
*
* MODEL ZENER: Is=1e-14 N=1 BV=5.1  (diode)

Vloop supply 0 DC 24
Rcable1 supply sensor_p 10
Lcable1 sensor_p sensor_p2 100u
Rcable2 sensor_n rcv_n 10
Lcable2 rcv_n rcv_n2 100u
Itx sensor_p2 sensor_n DC 12m
D1 rcv_n2 supply ZENER
D2 0 rcv_n2 ZENER
Rprot rcv_n2 vsense 100
Rsense vsense 0 250
Rfilter vsense vfilt 10k
Cfilter vfilt 0 160n
Radc vfilt 0 1MEG
Cadc vfilt 0 10p

.end
