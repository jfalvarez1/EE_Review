* Case Study: Industrial 4-20mA Sensor Interface - m23l04
* from lessons/module-23/lesson-04.html (build table 1)
* EE_Review corpus. Node 'ground', 'gnd', 'agnd', 'dgnd' all map to 0.
* EE_Review solve-dc: skip: nonlinear or switched part: D1 (Diode)
* EE_Review solve-op: solved
* UNSUPPORTED: D2: explicit zener BV=8.2 V, RZ=7 ohm requires a configured model; default ZENER is 5.1 V, 7 ohm
*
* MODEL 1N4148: Is=2.52e-9 N=1.752  (diode)

Vloop supply 0 DC 24
Rcable1 supply sensor_p 10
Lcable1 sensor_p sensor_p2 100u
Rcable2 sensor_n rcv_n 10
Lcable2 rcv_n rcv_n2 100u
Itx sensor_p2 sensor_n DC 12m
D1 rcv_n2 supply 1N4148
* UNSUPPORTED: D2: explicit zener BV=8.2 V, RZ=7 ohm requires a configured model; default ZENER is 5.1 V, 7 ohm; anode 0, cathode rcv_n2
Rprot rcv_n2 vsense 100
Rsense vsense 0 250
Rfilter vsense vfilt 10k
Cfilter vfilt 0 160n
Radc vfilt 0 1MEG
Cadc vfilt 0 10p

.end
