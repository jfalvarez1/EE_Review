* Log/Antilog Amplifiers - m08l04
* from lessons/module-08/lesson-04.html (build table 1)
* EE_Review corpus. Node 'ground', 'gnd', 'agnd', 'dgnd' all map to 0.
* EE_Review solve-dc: skip: nonlinear or switched part: Q1 (Transistor (BJT))
* EE_Review solve-op: solved
*
* MODEL NPN: Is=1e-14 BF=100 BR=1 NF=1  (npn)

VIN input 0 DC 100m
RIN input sumnode 10k
XU1 0 sumnode vout OPAMP
* fallback if X is unavailable: EU1 vout 0 0 sumnode 100k
Q1 sumnode 0 vout NPN
VCC vcc 0 DC 15
VEE vee 0 DC -15

.end
