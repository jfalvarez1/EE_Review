* Capacitive Sensing - m18l08
* from lessons/module-18/lesson-08.html (build table 1)
* EE_Review corpus. Node 'ground', 'gnd', 'agnd', 'dgnd' all map to 0.
* EE_Review's own solvers skip this one: time-varying source, no single DC value: I_charge
* EE_Review solve-dc: skip: time-varying source, no single DC value: I_charge
* EE_Review solve-op: skip: time-varying source, no single DC value: I_charge

C_int v_int 0 10p
R_reset v_int 0 10MEG
I_charge 0 v_int PULSE(0 1u 0 1n 1n 1u 10u)
E_buffer v_out 0 v_int 0 1

.end
