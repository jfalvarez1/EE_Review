* Delta-Sigma (ΣΔ) Conversion - m17l04
* from lessons/module-17/lesson-04.html (build table 1)
* EE_Review corpus. Node 'ground', 'gnd', 'agnd', 'dgnd' all map to 0.
* EE_Review solve-dc: solved
* EE_Review solve-op: skip: no semiconductors

VIN in 0 DC 500m
XU1 sum fb int OPAMP
* fallback if X is unavailable: EU1 int 0 sum fb 100k
RINT sum int 10k
CINT int 0 1n
XU2 int 0 comp OPAMP
* fallback if X is unavailable: EU2 comp 0 int 0 100k
EDAC fb 0 comp 0 0.5
RSUM1 in sum 10k
RSUM2 fb sum 10k
VCC vcc 0 DC 2.5
VEE vee 0 DC -2.5

.end
