* I2C Repeaters and Buffers - m20l07
* from lessons/module-20/lesson-07.html (build table 1)
* EE_Review corpus. Node 'ground', 'gnd', 'agnd', 'dgnd' all map to 0.
* EE_Review's own solvers skip this one: time-varying source, no single DC value: VGATE
* EE_Review solve-dc: skip: nonlinear or switched part: M1 (Transistor (MOSFET))
* EE_Review solve-op: skip: time-varying source, no single DC value: VGATE
*
* MODEL NMOS: Vth=0.7 Kp=0.00011 WL=10 K=0.0011 lambda=0.04  (nmos)

VCC1 vcc1 0 DC 3.3
RP1 vcc1 sda_unbuf 2.2k
CBUS sda_unbuf 0 400p
M1 sda_unbuf gate 0 NMOS W=10u L=1u LAMBDA=0.04 VTO=0.7 KP=110u
VGATE gate 0 PULSE(3.3 0 0 1n 1n 1u 2u)
VCC2 vcc2 0 DC 3.3
RP2A vcc2 sda_a 2.2k
CA sda_a 0 100p
RP2B vcc2 sda_b 2.2k
CB sda_b 0 300p
EBUF sda_b 0 sda_a 0 1
M2 sda_a gate 0 NMOS W=10u L=1u LAMBDA=0.04 VTO=0.7 KP=110u

.end
