* Case Study: Switching Power Supply Failure - m23l09
* from lessons/module-23/lesson-09.html (build table 1)
* EE_Review corpus. Node 'ground', 'gnd', 'agnd', 'dgnd' all map to 0.
* EE_Review's own solvers skip this one: open-loop comparator: U1
* EE_Review solve-dc: skip: nonlinear or switched part: D1 (Diode)
* EE_Review solve-op: skip: open-loop comparator: U1
*
* MODEL 1N4148: Is=2.52e-9 N=1.752  (diode)

Vaux aux_ac 0 SIN(0 15 100k) AC 15
D1 aux_ac vcc_raw 1N4148
Resr vcc_raw vcc_cap 8
Cfilt vcc_cap 0 47u
Rload vcc_cap 0 1k
Vth uvlo_th 0 DC 8
XU1 vcc_cap uvlo_th uvlo_out OPAMP
* fallback if X is unavailable: EU1 uvlo_out 0 vcc_cap uvlo_th 100k

.end
