* 555 Timer Circuits - m09l04
* from lessons/module-09/lesson-04.html (build table 1)
* EE_Review corpus. Node 'ground', 'gnd', 'agnd', 'dgnd' all map to 0.
* EE_Review's own solvers skip this one: open-loop comparator: U1
* EE_Review solve-dc: skip: open-loop comparator: U1
* EE_Review solve-op: skip: open-loop comparator: U1
* UNSUPPORTED: FF1: subcircuit instance (SR Latch)
* UNSUPPORTED: U3: subcircuit instance (NOT Gate)
*
* MODEL NMOS: Vth=0.7 Kp=0.00011 WL=10 K=0.0011 lambda=0.04  (nmos)

VCC vcc 0 DC 5
RA vcc ct 5k
RB ct cb 5k
RC cb 0 5k
XU1 thr ct setq OPAMP
* fallback if X is unavailable: EU1 setq 0 thr ct 100k
XU2 cb thr rstq OPAMP
* fallback if X is unavailable: EU2 rstq 0 cb thr 100k
XFF1 S setq reset_rstq q SR_LATCH
M1 dis q 0 NMOS W=10u L=1u LAMBDA=0.04 VTO=0.7 KP=110u
XU3 q out NOT_GATE
R1 vcc dis 10k
R2 dis thr 10k
C1 thr 0 100n
CBYP vcc 0 100n

.end
