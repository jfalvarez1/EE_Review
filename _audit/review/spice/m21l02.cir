* Low Noise Amplifiers (LNA) - m21l02
* from lessons/module-21/lesson-02.html (build table 1)
* EE_Review corpus. Node 'ground', 'gnd', 'agnd', 'dgnd' all map to 0.
* EE_Review solve-dc: skip: nonlinear or switched part: M1 (Transistor (MOSFET))
* EE_Review solve-op: solved
*
* MODEL NMOS: Vth=0.7 Kp=0.00011 WL=10 K=0.0011 lambda=0.04  (nmos)

VDD vdd 0 DC 1.8
Vbias1 vb1 0 DC 700m
Vbias2 vb2 0 DC 1.2
Vin rfin 0 SIN(0 10m 2.4G) AC 10m
Rs rfin in_coup 50
Cin in_coup lg_in 10p
Lg lg_in gate1 8.5n
Rbias gate1 vb1 10k
Cbias gate1 0 10p
M1 drain1 gate1 source1 NMOS W=10u L=1u LAMBDA=0.04 VTO=0.7 KP=110u
Ls source1 0 800p
M2 drain2 vb2 drain1 NMOS W=10u L=1u LAMBDA=0.04 VTO=0.7 KP=110u
Ld drain2 vdd 5n
Rld drain2 vdd 5
Cout drain2 out_match 2p
Lmatch out_match rfout 3n
RL rfout 0 50

.end
