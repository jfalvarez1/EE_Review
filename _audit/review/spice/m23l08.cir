* Case Study: Vintage Audio Amplifier Repair - m23l08
* from lessons/module-23/lesson-08.html (build table 1)
* EE_Review corpus. Node 'ground', 'gnd', 'agnd', 'dgnd' all map to 0.
* EE_Review solve-dc: skip: nonlinear or switched part: Q3 (Transistor (BJT))
* EE_Review solve-op: solved
*
* MODEL NPN: Is=1e-14 BF=100 BR=1 NF=1  (npn)
* MODEL PNP: Is=1e-14 BF=100 BR=1 NF=1  (pnp)

Vcc vcc 0 DC 35
Vee vee 0 DC -35
Ibias vcc d1 DC 10m
Q3 d1 bias d2 NPN
R1 d1 bias 1k
R2 bias d2 1k
Vdrive d2 0 DC -755m SIN(-755m 4 1k) AC 4
Q4 vcc d1 e4 NPN
Q5 vee d2 e5 PNP
RE1 e4 out 330m
RE2 e5 out 330m
Rload out 0 8

.end
