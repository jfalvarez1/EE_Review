* Case Study: Vintage Audio Amplifier Repair - m23l08
* from lessons/module-23/lesson-08.html (build table 1)
* EE_Review corpus. Node 'ground', 'gnd', 'agnd', 'dgnd' all map to 0.
* EE_Review solve-dc: skip: nonlinear or switched part: Q1 (Transistor (BJT))
* EE_Review solve-op: solved
*
* MODEL NPN: Is=1e-14 BF=100 BR=1 NF=1  (npn)
* MODEL PNP: Is=1e-14 BF=100 BR=1 NF=1  (pnp)

Vcc vcc 0 DC 35
Vee vee 0 DC -35
Vin in 0 SIN(0 2 1k) AC 2
Q1 vcc in d1 NPN
Q2 vee in d2 PNP
Q3 d1 bias bias NPN
Rbias1 bias d2 1k
Rbias2 d1 bias 470
Q4 vcc d1 e4 NPN
Q5 vee d2 e5 PNP
Re4 e4 out 330m
Re5 e5 out 330m
Rload out 0 8

.end
