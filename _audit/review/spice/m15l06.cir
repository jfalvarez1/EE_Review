* Battery Management System Integration - m15l06
* from lessons/module-15/lesson-06.html (build table 1)
* EE_Review corpus. Node 'ground', 'gnd', 'agnd', 'dgnd' all map to 0.
* EE_Review solve-dc: skip: nonlinear or switched part: M_dsg (NMOS)
* EE_Review solve-op: solved
*
* MODEL DIODE: Is=1e-14 N=1  (diode)
* MODEL NMOS: Vth=0.7 Kp=0.00011 WL=10 K=0.0011 lambda=0.04  (nmos)

V_cell1 cell1_int 0 DC 3.7
R_int1 cell1_int cell1_pos 30m
V_cell2 cell2_int cell1_pos DC 3.7
R_int2 cell2_int cell2_pos 30m
V_cell3 cell3_int cell2_pos DC 3.7
R_int3 cell3_int cell3_pos 30m
V_cell4 cell4_int cell3_pos DC 3.7
R_int4 cell4_int pack_plus 30m
R_sense 0 sense 5m
M_dsg fet_mid dsg_g sense NMOS W=200m L=1u LAMBDA=0.04 VTO=0.7 KP=110u
D_dsg sense fet_mid DIODE
V_dsg dsg_g sense DC 12
M_chg fet_mid chg_g pack_minus NMOS W=200m L=1u LAMBDA=0.04 VTO=0.7 KP=110u
D_chg pack_minus fet_mid DIODE
V_chg chg_g pack_minus DC 12
R_load pack_plus pack_minus 2
I_charger pack_minus pack_plus DC 0

.end
