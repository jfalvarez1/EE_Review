* Battery Management System Integration - m15l06
* from lessons/module-15/lesson-06.html (build table 1)
* EE_Review corpus. Node 'ground', 'gnd', 'agnd', 'dgnd' all map to 0.
* EE_Review's own solvers skip this one: no ground node: nothing to measure from
* EE_Review solve-dc: skip: nonlinear or switched part: M_chg (Transistor (MOSFET))
* EE_Review solve-op: skip: no ground node: nothing to measure from
*
* MODEL PMOS: Vth=0.7 Kp=0.00011 WL=10 K=0.0011 lambda=0.04  (pmos)

V_cell1 pack_plus n1 DC 3.7
R_int1 n1 n1a 30m
V_cell2 n1a n2 DC 3.7
R_int2 n2 n2a 30m
V_cell3 n2a n3 DC 3.7
R_int3 n3 n3a 30m
V_cell4 n3a pack_minus DC 3.7
R_int4 pack_minus pack_gnd 30m
M_chg pack_plus chg_mid chg_gate PMOS W=10u L=1u LAMBDA=0.04 VTO=0.7 KP=110u
M_dsg chg_mid load_plus dsg_gate PMOS W=10u L=1u LAMBDA=0.04 VTO=0.7 KP=110u
R_shunt load_plus load_out 5m
R_load load_out pack_gnd 2
V_chg_ctrl chg_gate pack_plus DC 0
V_dsg_ctrl dsg_gate pack_plus DC 0

.end
