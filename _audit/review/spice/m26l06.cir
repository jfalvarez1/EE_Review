* High-Precision DAQ System - m26l06
* from lessons/module-26/lesson-06.html (build table 1)
* EE_Review corpus. Node 'ground', 'gnd', 'agnd', 'dgnd' all map to 0.
* EE_Review solve-dc: solved
* EE_Review solve-op: skip: no semiconductors

Vin_ IN_ 0 AC 1m
Vin_ IN_ 0 DC 0
Rin_ IN_ N1 10k
Rin_ IN_ N2 10k
C1 N1 N2 100n
E_IA OUT 0 N1 N2 64
Rout_IA OUT N3 100
R_filt N3 N4 1k
C_filt N4 0 1u
E_buf VOUT 0 N4 0 1
Rout_buf VOUT ADC_IN 10
Vref REF 0 DC 2.048
Rref REF 0 1G

.end
