* BLDC Motor Driver Design - m25l06
* from lessons/module-25/lesson-06.html (build table 1)
* EE_Review corpus. Node 'ground', 'gnd', 'agnd', 'dgnd' all map to 0.
* EE_Review's own solvers skip this one: time-varying source, no single DC value: Vg1
* EE_Review solve-dc: skip: nonlinear or switched part: M1 (Transistor (MOSFET))
* EE_Review solve-op: skip: time-varying source, no single DC value: Vg1
*
* MODEL NMOS: Vth=0.7 Kp=0.00011 WL=10 K=0.0011 lambda=0.04  (nmos)

VDC vdc 0 DC 48
Cbus vdc 0 100u
M1 vdc gate1 phase NMOS W=10u L=1u LAMBDA=0.04 VTO=0.7 KP=110u
M2 phase gate2 0 NMOS W=10u L=1u LAMBDA=0.04 VTO=0.7 KP=110u
Vg1 gate1 phase PULSE(0 10 0 1n 1n -999.976m 50u)
Vg2 gate2 0 PULSE(0 10 0 1n 1n -26 50u)
Lm phase vout 1m
Rm vout 0 5

.end
