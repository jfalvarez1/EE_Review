* Data Acquisition System Architecture - m25l15
* from lessons/module-25/lesson-15.html (build table 1)
* EE_Review corpus. Node 'ground', 'gnd', 'agnd', 'dgnd' all map to 0.
* EE_Review solve-dc: solved
* EE_Review solve-op: skip: no semiconductors

Vin IN 0 SIN(0 1 100) AC 1
R1 IN 1 15.9k
R2 1 2 15.9k
C1 1 0 10n
C2 2 OUT 20n
E1 OUT 0 2 OUT 1000000
Rload OUT 0 10k

.end
