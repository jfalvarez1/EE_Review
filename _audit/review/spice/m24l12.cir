* Power Supply Debugging: Measurement and Common Faults - m24l12
* from lessons/module-24/lesson-12.html (build table 1)
* EE_Review corpus. Node 'ground', 'gnd', 'agnd', 'dgnd' all map to 0.
* EE_Review's own solvers skip this one: time-varying source, no single DC value: VSW
* EE_Review solve-dc: skip: time-varying source, no single DC value: VSW
* EE_Review solve-op: skip: time-varying source, no single DC value: VSW

VSW sw 0 PULSE(0 12 0 1000p 1000p 500n 1u)
L_OUT sw lx 10u
R_DCR lx out 20m
R_ESR_BULK out out_esr 10m
C_BULK out_esr 0 100u
R_ESR_MLCC out out_mlcc 2m
C_MLCC out_mlcc 0 22u
ILOAD out 0 PULSE(0 2 0 1n 1n 10u 50u)

.end
