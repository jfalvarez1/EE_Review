* MOSFET Fundamentals - m06l01-6
* from lessons/module-06/lesson-01.html (build table 6)
* EE_Review corpus. Node 'ground', 'gnd', 'agnd', 'dgnd' all map to 0.
* EE_Review solve-dc: skip: nonlinear or switched part: M1 (Transistor (MOSFET))
* EE_Review solve-op: solved
*
* MODEL NMOS: Vth=0.7 Kp=0.00011 WL=10 K=0.0011 lambda=0.04  (nmos)

VDD vdd 0 DC 10
VIN gate 0 DC 5
M1 vdd gate source NMOS W=10u L=1u LAMBDA=0.04 VTO=0.7 KP=110u
RS source 0 1k

.end
