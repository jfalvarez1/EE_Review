* Phase-Locked Loop (PLL) Basics - m08l01
* from lessons/module-08/lesson-01.html (build table 1)
* EE_Review corpus. Node 'ground', 'gnd', 'agnd', 'dgnd' all map to 0.
* EE_Review's own solvers skip this one: time-varying source, no single DC value: VREF
* EE_Review solve-dc: skip: time-varying source, no single DC value: VREF
* EE_Review solve-op: skip: time-varying source, no single DC value: VREF
* UNSUPPORTED: XOR1: subcircuit instance (XOR Gate)
* UNSUPPORTED: VCO1: subcircuit instance (VCO)

VREF ref 0 PULSE(0 1 0 50p 50p 25n 50n)
XOR1 s_ref vco pd_out XOR_GATE
R1 pd_out lf 1k
C1 lf 0 1n
R2 lf lf2 100
C2 lf2 0 100p
XVCO1 control_lf2 vco VCO

.end
