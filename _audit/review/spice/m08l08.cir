* Voltage-Controlled Oscillators and Filters - m08l08
* from lessons/module-08/lesson-08.html (build table 1)
* EE_Review corpus. Node 'ground', 'gnd', 'agnd', 'dgnd' all map to 0.
* EE_Review's own solvers skip this one: open-loop comparator: U1
* EE_Review solve-dc: skip: open-loop comparator: U1
* EE_Review solve-op: skip: open-loop comparator: U1
* UNSUPPORTED: FF1: subcircuit instance (SR Latch)
* UNSUPPORTED: U3: subcircuit instance (NOT Gate)
*
* MODEL NMOS: Vth=0.7 Kp=0.00011 WL=10 K=0.0011 lambda=0.04  (nmos)

Vctrl ctrl 0 DC 2.5
Rchg ctrl cap 100k
C1 cap 0 100p
Vth_hi vth_hi 0 DC 1.5
Vth_lo vth_lo 0 DC 1
XU1 cap vth_hi setq OPAMP
* fallback if X is unavailable: EU1 setq 0 cap vth_hi 100k
XU2 vth_lo cap rstq OPAMP
* fallback if X is unavailable: EU2 rstq 0 vth_lo cap 100k
XFF1 S setq reset_rstq q SR_LATCH
M1 cap q 0 NMOS W=10u L=1u LAMBDA=0.04 VTO=0.7 KP=110u
XU3 q out NOT_GATE
Rload out 0 10k

.end
