* Design Exercise: Precision Sensor Amplifier - m12l15
* from lessons/module-12/lesson-15.html (build table 1)
* EE_Review corpus. Node 'ground', 'gnd', 'agnd', 'dgnd' all map to 0.
* EE_Review's own solvers skip this one: nonlinear or switched part: XINA (Block (INA128))
* EE_Review solve-dc: skip: nonlinear or switched part: XINA (Block (INA128))
* EE_Review solve-op: skip: nonlinear or switched part: XINA (Block (INA128))
* UNSUPPORTED: XINA: subcircuit instance (Block (INA128))

VSENS inp inn SIN(0 25m 10) AC 25m
RIN1 inp in1_f 1k
CIN1 in1_f 0 10n
RIN2 inn in2_f 1k
CIN2 in2_f 0 10n
XINA in1_f in2_f ina_out 0 rg1 rg2 vcc vee INA128
RG rg1 rg2 5.55k
EGAIN2 out2 0 ina_out 0 8.2
RAF out2 filt1 64k
RBF filt1 filt2 64k
CAF filt1 0 100n
CBF filt2 adc_in 100n
EBUF adc_in 0 filt2 0 1
VCC vcc 0 DC 5
VEE vee 0 DC -5

.end
