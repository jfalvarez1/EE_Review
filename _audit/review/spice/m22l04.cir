* Surge Protection - m22l04
* from lessons/module-22/lesson-04.html (build table 1)
* EE_Review corpus. Node 'ground', 'gnd', 'agnd', 'dgnd' all map to 0.
* EE_Review's own solvers skip this one: time-varying source, no single DC value: Vsurge
* EE_Review solve-dc: skip: time-varying source, no single DC value: Vsurge
* EE_Review solve-op: skip: time-varying source, no single DC value: Vsurge
* UNSUPPORTED: Dmov1: zener with no stated breakdown voltage (assumed BV = 5.1 V)
* UNSUPPORTED: Dmov2: zener with no stated breakdown voltage (assumed BV = 5.1 V)
* UNSUPPORTED: Dtvs1: zener with no stated breakdown voltage (assumed BV = 5.1 V)
* UNSUPPORTED: Dtvs2: zener with no stated breakdown voltage (assumed BV = 5.1 V)
*
* MODEL ZENER: Is=1e-14 N=1 BV=5.1  (diode)

Vsurge IN 0 DC 0
Rsrc IN N1 2
Rmov N1 N2 1G
Dmov1 N2 0 ZENER
Dmov2 0 N2 ZENER
L1 N2 N3 10u
Rdamp N3 N4 500m
Dtvs1 N4 0 ZENER
Dtvs2 0 N4 ZENER
C1 N4 0 100n
Rload N4 0 1k

.end
