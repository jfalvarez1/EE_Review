* Surge Protection - m22l04
* from lessons/module-22/lesson-04.html (build table 1)
* EE_Review corpus. Node 'ground', 'gnd', 'agnd', 'dgnd' all map to 0.
* EE_Review's own solvers skip this one: time-varying source, no single DC value: Vsurge
* EE_Review solve-dc: skip: time-varying source, no single DC value: Vsurge
* EE_Review solve-op: skip: time-varying source, no single DC value: Vsurge
* UNSUPPORTED: Dmov1: explicit zener BV=430 V, RZ=2.8 ohm requires a configured model; default ZENER is 5.1 V, 7 ohm
* UNSUPPORTED: Dmov2: explicit zener BV=430 V, RZ=2.8 ohm requires a configured model; default ZENER is 5.1 V, 7 ohm
* UNSUPPORTED: Dtvs1: explicit zener BV=40 V, RZ=1.76 ohm requires a configured model; default ZENER is 5.1 V, 7 ohm
* UNSUPPORTED: Dtvs2: explicit zener BV=40 V, RZ=1.76 ohm requires a configured model; default ZENER is 5.1 V, 7 ohm

Vsurge IN 0 PULSE(0 2k 0 1n 1n 500u 1m)
Rsrc IN N2 2
* UNSUPPORTED: Dmov1: explicit zener BV=430 V, RZ=2.8 ohm requires a configured model; default ZENER is 5.1 V, 7 ohm; anode mov_mid, cathode N2
* UNSUPPORTED: Dmov2: explicit zener BV=430 V, RZ=2.8 ohm requires a configured model; default ZENER is 5.1 V, 7 ohm; anode mov_mid, cathode 0
L1 N2 N3 10u
Rdamp N3 N4 500m
* UNSUPPORTED: Dtvs1: explicit zener BV=40 V, RZ=1.76 ohm requires a configured model; default ZENER is 5.1 V, 7 ohm; anode tvs_mid, cathode N4
* UNSUPPORTED: Dtvs2: explicit zener BV=40 V, RZ=1.76 ohm requires a configured model; default ZENER is 5.1 V, 7 ohm; anode tvs_mid, cathode 0
C1 N4 0 100n
Rload N4 0 1k

.end
