* Battery Chemistry Selection - m15l05
* from lessons/module-15/lesson-05.html (build table 1)
* EE_Review corpus. Node 'ground', 'gnd', 'agnd', 'dgnd' all map to 0.
* EE_Review solve-dc: solved
* EE_Review solve-op: skip: no semiconductors

V_ocv ocv 0 DC 3.9
R_int ocv pos 50m
Rload pos 0 1

.end
