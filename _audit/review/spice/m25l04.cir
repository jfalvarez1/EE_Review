* Current Sensing Applications - m25l04
* from lessons/module-25/lesson-04.html (build table 1)
* EE_Review corpus. Node 'ground', 'gnd', 'agnd', 'dgnd' all map to 0.
* EE_Review solve-dc: solved
* EE_Review solve-op: skip: no semiconductors

Vdd vdd 0 DC 12
Iload vdd load_n DC 5
Rsense load_n load 10m
Rload load 0 2.4
Esense out 0 load_n load 50

.end
