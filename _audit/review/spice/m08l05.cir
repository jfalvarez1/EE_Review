* Sample and Hold Circuits - m08l05
* from lessons/module-08/lesson-05.html (build table 1)
* EE_Review corpus. Node 'ground', 'gnd', 'agnd', 'dgnd' all map to 0.
* EE_Review's own solvers skip this one: time-varying source, no single DC value: VCLK
* EE_Review solve-dc: skip: time-varying source, no single DC value: VCLK
* EE_Review solve-op: skip: time-varying source, no single DC value: VCLK
* UNSUPPORTED: X1: subcircuit instance (Block (sample and hold))

VIN input 0 SIN(0 2 1k) AC 2
VCLK clk 0 PULSE(5 0 0 1n 1n 5u 10u)
VCC vcc 0 DC 5
X1 clk vcc 0 SAMPLE_AND_HOLD

.end
