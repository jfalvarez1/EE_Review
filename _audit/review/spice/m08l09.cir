* Charge Pumps - m08l09
* from lessons/module-08/lesson-09.html (build table 1)
* EE_Review corpus. Node 'ground', 'gnd', 'agnd', 'dgnd' all map to 0.
* EE_Review's own solvers skip this one: time-varying source, no single DC value: Vclk1
* EE_Review solve-dc: skip: time-varying source, no single DC value: Vclk1
* EE_Review solve-op: skip: time-varying source, no single DC value: Vclk1
* UNSUPPORTED: S1: subcircuit instance (Analog Switch)
* UNSUPPORTED: S2: subcircuit instance (Analog Switch)
* UNSUPPORTED: S3: subcircuit instance (Analog Switch)
* UNSUPPORTED: S4: subcircuit instance (Analog Switch)

Vin in 0 DC 3.3
Vclk1 clk1 0 PULSE(0 5 0 900p 900p 400n 900n)
Vclk2 clk2 0 PULSE(0 5 0 900p 900p -450 900n)
XS1 in cflyp clk1 ANALOG_SWITCH_MDASH_CHARGE_PHASE
XS2 cflyn 0 clk1 ANALOG_SWITCH_MDASH_CHARGE_PHASE
XS3 in cflyn clk2 ANALOG_SWITCH_MDASH_PUMP_PHASE
XS4 cflyp out clk2 ANALOG_SWITCH_MDASH_PUMP_PHASE
Cfly cflyp cflyn 1u
Cout out 0 10u
Rload out 0 660

.end
