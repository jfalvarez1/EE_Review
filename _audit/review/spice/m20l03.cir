* UART RS-232/RS-485 Transceivers - m20l03
* from lessons/module-20/lesson-03.html (build table 1)
* EE_Review corpus. Node 'ground', 'gnd', 'agnd', 'dgnd' all map to 0.
* EE_Review's own solvers skip this one: time-varying source, no single DC value: VDATA
* EE_Review solve-dc: skip: time-varying source, no single DC value: VDATA
* EE_Review solve-op: skip: time-varying source, no single DC value: VDATA

VCM cm 0 DC 2.5
E_A a_drv cm data 0 1
E_B b_drv cm data 0 -1
RDA a_drv a_line 50
RDB b_drv b_line 50
RLINE_A a_line a_rcv 10
RLINE_B b_line b_rcv 10
CLINE_A a_rcv 0 100p
CLINE_B b_rcv 0 100p
RTERM a_rcv b_rcv 120
VN_CM noise 0 SIN(0 1 60) AC 1
E_NOISE_A a_rcv_noisy a_rcv noise 0 1
E_NOISE_B b_rcv_noisy b_rcv noise 0 1
E_DIFF diff 0 a_rcv_noisy b_rcv_noisy 1
VDATA data 0 PULSE(-1 1 0 1n 1n 2.17u 4.34u)

.end
