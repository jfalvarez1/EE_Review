* Case Study: Automotive ECU Power System - m23l05
* from lessons/module-23/lesson-05.html (build table 1)
* EE_Review corpus. Node 'ground', 'gnd', 'agnd', 'dgnd' all map to 0.
* EE_Review's own solvers skip this one: nonlinear or switched part: Xbuck (Block (buck regulator))
* EE_Review solve-dc: skip: nonlinear or switched part: M1 (Transistor (MOSFET))
* EE_Review solve-op: skip: nonlinear or switched part: Xbuck (Block (buck regulator))
* UNSUPPORTED: D1: zener with no stated breakdown voltage (assumed BV = 5.1 V)
* UNSUPPORTED: D2: zener with no stated breakdown voltage (assumed BV = 5.1 V)
* UNSUPPORTED: Xbuck: subcircuit instance (Block (buck regulator))
* UNSUPPORTED: Xldo: subcircuit instance (Block (LDO regulator))
*
* MODEL PMOS: Vth=0.7 Kp=0.00011 WL=10 K=0.0011 lambda=0.04  (pmos)
* MODEL ZENER: Is=1e-14 N=1 BV=5.1 RZ=7  (diode)

Vbat bat 0 DC 13.5
M1 bat gate prot PMOS W=10u L=1u LAMBDA=0.04 VTO=0.7 KP=110u
Rgate gate prot 10k
Rseries prot filtered 10
D1 filtered 0 ZENER
D2 0 filtered ZENER
Cin filtered 0 100u
Xbuck filtered rail5v BUCK_REGULATOR
Xldo rail5v rail3v3 LDO_REGULATOR

.end
