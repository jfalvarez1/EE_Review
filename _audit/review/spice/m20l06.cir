* CAN Bus Physical Layer - m20l06
* from lessons/module-20/lesson-06.html (build table 1)
* EE_Review corpus. Node 'ground', 'gnd', 'agnd', 'dgnd' all map to 0.
* EE_Review's own solvers skip this one: time-varying source, no single DC value: VTX1
* EE_Review solve-dc: skip: time-varying source, no single DC value: VTX1
* EE_Review solve-op: skip: time-varying source, no single DC value: VTX1
* UNSUPPORTED: X1: subcircuit instance (Block (CAN transceiver))
* UNSUPPORTED: X2: subcircuit instance (Block (CAN transceiver))

VCC vcc 0 DC 5
VTX1 txd1 0 PULSE(5 0 0 1000p 1000p 500n 1u)
X1 txd1 rxd1 canh1 canl1 vcc 0 CAN_TRANSCEIVER
RT1 canh1 canl1 120
TH canh1 canh2 60 5n
TL canl1 canl2 60 5n
RT2 canh2 canl2 120
VTX2 txd2 0 DC 5
X2 txd2 rxd2 canh2 canl2 vcc 0 CAN_TRANSCEIVER

.end
