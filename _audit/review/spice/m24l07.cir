* Debugging Thermal Problems - m24l07
* from lessons/module-24/lesson-07.html (build table 1)
* EE_Review corpus. Node 'ground', 'gnd', 'agnd', 'dgnd' all map to 0.
* EE_Review solve-dc: solved
* EE_Review solve-op: skip: no semiconductors

Ipower 0 junction DC 2
Rjc junction case 10
Cj junction 0 100m
Rcs case sink 5
Cc case 0 500m
Rsa sink ambient 20
Cs sink 0 5
Vambient ambient 0 DC 25

.end
