* Body Effect & Back Gate (The 4th MOSFET Terminal) - m06l07
* from lessons/module-06/lesson-07.html (build table 1)
* EE_Review corpus. Node 'ground', 'gnd', 'agnd', 'dgnd' all map to 0.
* EE_Review solve-dc: skip: nonlinear or switched part: M1 (Transistor (MOSFET))
* EE_Review solve-op: solved
*
* MODEL NMOS: Vth=0.7 Kp=0.00011 WL=10 K=0.0011 lambda=0.04  (nmos)

VDD vdd 0 DC 3.3
VIN in 0 DC 0
RD1 vdd d1 2k
RD2 vdd d2 2k
M1 d1 in s1 NMOS W=10u L=1u LAMBDA=0.04 VTO=0.7 KP=110u
M2 d2 in s2 NMOS W=10u L=1u LAMBDA=0.04 VTO=0.7 KP=110u
RS1 s1 0 1k
RS2 s2 0 1k

.end
