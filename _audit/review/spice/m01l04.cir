* Bandwidth and Slew Rate - m01l04
* from lessons/module-01/lesson-04.html (build table 1)
* EE_Review corpus. Node 'ground', 'gnd', 'agnd', 'dgnd' all map to 0.
* EE_Review's own solvers skip this one: nonlinear or switched part: U1 (Op-amp)
* EE_Review solve-dc: skip: nonlinear or switched part: U1 (Op-amp)
* EE_Review solve-op: skip: nonlinear or switched part: U1 (Op-amp)

XU1 inp inv out OPAMP
* fallback if X is unavailable: EU1 out 0 inp inv 100k
R1 0 inv 10k
RF inv out 90k
RLOAD out 0 10k
VIN_AC inp 0 AC 100m
VIN_SLEW inp 0 PULSE(-5 5 0 1n 1n 2.5u 5u)

.end
