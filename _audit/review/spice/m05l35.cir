* Power BJTs and Thermal Design - m05l35
* from lessons/module-05/lesson-35.html (build table 1)
* EE_Review corpus. Node 'ground', 'gnd', 'agnd', 'dgnd' all map to 0.
* EE_Review's own solvers skip this one: time-varying source, no single DC value: VIN
* EE_Review solve-dc: skip: time-varying source, no single DC value: VIN
* EE_Review solve-op: skip: time-varying source, no single DC value: VIN
*
* MODEL NPN: Is=1e-14 BF=100 BR=1 NF=1  (npn)

VCC 1 0 DC 24
VIN 3 0 PULSE(0 5 0 1n 1n 5m 10m)
RB 3 2 100
Q1 1 2 4 NPN
RL 4 0 10

.end
