* Scenario: Audio DAC Output Stage - m18l04
* from lessons/module-18/lesson-04.html (build table 1)
* EE_Review corpus. Node 'ground', 'gnd', 'agnd', 'dgnd' all map to 0.
* EE_Review's own solvers skip this one: nonlinear or switched part: XAMP (Block (audio op-amp))
* EE_Review solve-dc: skip: nonlinear or switched part: XAMP (Block (audio op-amp))
* EE_Review solve-op: skip: nonlinear or switched part: XAMP (Block (audio op-amp))
* UNSUPPORTED: XAMP: subcircuit instance (Block (audio op-amp))

VCC vcc 0 DC 12
VEE vee 0 DC -12
VIN inp 0 SIN(0 1 1k) AC 1
XAMP inp fb out vcc vee REAL_OP_AMP
R1 out fb 10k
R2 fb 0 5k
COUT out hp_in 220u
RLOAD hp_in 0 32

.end
