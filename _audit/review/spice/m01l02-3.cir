* Golden Rules and Basic Configurations - m01l02-3
* from lessons/module-01/lesson-02.html (build table 3)
* EE_Review corpus. Node 'ground', 'gnd', 'agnd', 'dgnd' all map to 0.
* EE_Review solve-dc: solved
* EE_Review solve-op: skip: no semiconductors

VCC vcc 0 DC 12
VEE vee 0 DC -12
VIN in 0 DC 500m
XU1 0 vminus out OPAMP
* fallback if X is unavailable: EU1 out 0 0 vminus 100k
R1 in vminus 1k
RF vminus out 10k

.end
