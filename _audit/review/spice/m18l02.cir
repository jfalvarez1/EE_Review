* Scenario: Automotive 12V System EMC - m18l02
* from lessons/module-18/lesson-02.html (build table 1)
* EE_Review corpus. Node 'ground', 'gnd', 'agnd', 'dgnd' all map to 0.
* EE_Review's own solvers skip this one: time-varying source, no single DC value: VDUMP
* EE_Review solve-dc: skip: time-varying source, no single DC value: VDUMP
* EE_Review solve-op: skip: time-varying source, no single DC value: VDUMP
* UNSUPPORTED: D_TVS: explicit zener BV=26.7 V, RZ=0.07 ohm requires a configured model; default ZENER is 5.1 V, 7 ohm

VBATT batt 0 DC 13.5
VDUMP dump 0 PULSE(0 73.5 0 1n 1n 500u 1m)
EDUMP vsrc batt dump 0 1
RI vsrc vin 1
RPFET vin prot 50m
* UNSUPPORTED: D_TVS: explicit zener BV=26.7 V, RZ=0.07 ohm requires a configured model; default ZENER is 5.1 V, 7 ohm; anode 0, cathode prot
L_FILT prot filt 10u
R_DCR filt filt2 20m
C_IN filt2 0 100u
RLOAD filt2 0 10

.end
