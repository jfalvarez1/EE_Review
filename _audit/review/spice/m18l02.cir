* Scenario: Automotive 12V System EMC - m18l02
* from lessons/module-18/lesson-02.html (build table 1)
* EE_Review corpus. Node 'ground', 'gnd', 'agnd', 'dgnd' all map to 0.
* EE_Review's own solvers skip this one: time-varying source, no single DC value: VDUMP
* EE_Review solve-dc: skip: time-varying source, no single DC value: VDUMP
* EE_Review solve-op: skip: time-varying source, no single DC value: VDUMP
* UNSUPPORTED: D_TVS: zener with no stated breakdown voltage (assumed BV = 5.1 V)
*
* MODEL ZENER: Is=1e-14 N=1 BV=5.1 RZ=7  (diode)

VBATT batt_int 0 DC 13.5
RBATT batt_int batt 50m
VDUMP dump 0 PULSE(0 73.5 0 1n 1n 500u 1m)
VSUM batt vsum DC 0
EDUMP vin vsum dump 0 1
RPFET vin prot 50m
D_TVS prot 0 ZENER
L_FILT prot filt 10u
R_DCR filt filt2 20m
C_IN filt2 0 100u
RLOAD filt2 0 10

.end
