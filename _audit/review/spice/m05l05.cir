* DC Biasing Techniques - m05l05
* from lessons/module-05/lesson-05.html (build table 1)
* EE_Review corpus. Node 'ground', 'gnd', 'agnd', 'dgnd' all map to 0.
* EE_Review solve-dc: skip: nonlinear or switched part: Q1 (Transistor (BJT))
* EE_Review solve-op: solved
*
* MODEL 2N3904: Is=6.734e-15 BF=416.4 BR=0.7371 NF=1  (npn)

VCC vcc 0 DC 12
R1 vcc base 47k
R2 base 0 10k
Q1 col base emit 2N3904
RC vcc col 4.7k
RE emit 0 1k
VIN in 0 SIN(0 10m 1k) AC 10m
CIN in base 10u

.end
