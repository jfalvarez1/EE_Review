* Power Sequencing Design - m14l10
* from lessons/module-14/lesson-10.html (build table 1)
* EE_Review corpus. Node 'ground', 'gnd', 'agnd', 'dgnd' all map to 0.
* EE_Review's own solvers skip this one: nonlinear or switched part: Xreg1 (Block (regulator))
* EE_Review solve-dc: skip: nonlinear or switched part: Xreg1 (Block (regulator))
* EE_Review solve-op: skip: nonlinear or switched part: Xreg1 (Block (regulator))
* UNSUPPORTED: Xreg1: subcircuit instance (Block (regulator))
* UNSUPPORTED: Xreg2: subcircuit instance (Block (regulator))
* UNSUPPORTED: Xreg3: subcircuit instance (Block (regulator))

Vin vin 0 DC 5
Xreg1 vin en1 v1 pgood1 REGULATOR
Ven1 en1 0 PULSE(0 5 0 1n 1n 50m 100m)
Rdelay1 pgood1 en2 100k
Cdelay1 en2 0 100n
Xreg2 vin en2 v2 pgood2 REGULATOR
Rdelay2 pgood2 en3 100k
Cdelay2 en3 0 100n
Xreg3 vin en3 v3 pgood3 REGULATOR

.end
