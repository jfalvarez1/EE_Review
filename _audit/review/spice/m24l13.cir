* Signal Integrity Debugging: Measurement and Fixes - m24l13
* from lessons/module-24/lesson-13.html (build table 1)
* EE_Review corpus. Node 'ground', 'gnd', 'agnd', 'dgnd' all map to 0.
* EE_Review's own solvers skip this one: time-varying source, no single DC value: VPULSE
* EE_Review solve-dc: skip: time-varying source, no single DC value: VPULSE
* EE_Review solve-op: skip: time-varying source, no single DC value: VPULSE

VPULSE src 0 PULSE(0 3.3 0 10p 10p 5n 10n)
RSRC src drv 10
RLOAD load 0 1MEG

.end
