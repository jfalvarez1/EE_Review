* Sensor Interface Design - m25l08
* from lessons/module-25/lesson-08.html (build table 1)
* EE_Review corpus. Node 'ground', 'gnd', 'agnd', 'dgnd' all map to 0.
* EE_Review solve-dc: solved
* EE_Review solve-op: skip: no semiconductors

VEX vexc 0 DC 5
R1 vexc vp 120
R2 vexc vn 120
R3 vp 0 120
R4 vn 0 120
Vimbal vp vp_sense DC -10m
E1 out 0 vp_sense vn 100
Rout out vout_buf 100
Cout vout_buf 0 100p

.end
