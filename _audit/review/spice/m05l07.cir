* Emitter Follower (Common-Collector) - m05l07
* from lessons/module-05/lesson-07.html (build table 1)
* EE_Review corpus. Node 'ground', 'gnd', 'agnd', 'dgnd' all map to 0.
* EE_Review solve-dc: skip: nonlinear or switched part: Q1 (Transistor (BJT))
* EE_Review solve-op: solved
*
* MODEL 2N3904: Is=6.734e-15 BF=416.4 BR=0.7371 NF=1  (npn)

VCC 1 0 DC 12
VIN 2 0 SIN(0 1 1k) AC 1
R1 1 3 22k
R2 3 0 22k
Q1 1 3 4 2N3904
RE 4 0 2.2k
CIN 2 3 10u
COUT 4 5 10u
RL 5 0 1k

.end
