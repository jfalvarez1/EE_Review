* Analog Computation Circuits - m08l10
* from lessons/module-08/lesson-10.html (build table 1)
* EE_Review corpus. Node 'ground', 'gnd', 'agnd', 'dgnd' all map to 0.
* EE_Review's own solvers skip this one: time-varying source, no single DC value: Vin
* EE_Review solve-dc: skip: time-varying source, no single DC value: Vin
* EE_Review solve-op: skip: time-varying source, no single DC value: Vin
* UNSUPPORTED: Sreset: subcircuit instance (Analog Switch)

Vin in 0 PULSE(-1 1 0 1n 1n 2.5m 5m)
Rin in vm 10k
XUopamp 0 vm out OPAMP
* fallback if X is unavailable: EUopamp out 0 0 vm 100k
Cf vm out 1u
Vreset reset 0 PULSE(0 5 0 1n 1n 100u 25m)
XSreset vm out reset ANALOG_SWITCH

.end
