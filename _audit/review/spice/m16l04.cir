* Class D Amplifiers - m16l04
* from lessons/module-16/lesson-04.html (build table 1)
* EE_Review corpus. Node 'ground', 'gnd', 'agnd', 'dgnd' all map to 0.
* EE_Review's own solvers skip this one: nonlinear or switched part: M1 (Transistor (MOSFET, switching — low Rds(on)))
* EE_Review solve-dc: skip: nonlinear or switched part: M1 (Transistor (MOSFET, switching — low Rds(on)))
* EE_Review solve-op: skip: nonlinear or switched part: M1 (Transistor (MOSFET, switching — low Rds(on)))
*
* MODEL NMOS: Vth=0.7 Kp=0.00011 WL=10 K=0.0011 lambda=0.04  (nmos)
* MODEL PMOS: Vth=0.7 Kp=0.00011 WL=10 K=0.0011 lambda=0.04  (pmos)

VDD vdd 0 DC 12
VSS vss 0 DC -12
M1 vdd gate_h sw PMOS W=10u L=1u LAMBDA=0.04 VTO=0.7 KP=110u
M2 sw gate_l vss NMOS W=10u L=1u LAMBDA=0.04 VTO=0.7 KP=110u
VGATE_H gate_h 0 PULSE(-12 12 0 1n 1n 550n 1.1u)
VGATE_L gate_l 0 PULSE(12 -12 0 1n 1n 550n 1.1u)
L1 sw filt 22u
C1 filt 0 1u
RSPK filt 0 8

.end
