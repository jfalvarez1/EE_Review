* Flyback Converter Design - m14l06
* from lessons/module-14/lesson-06.html (build table 1)
* EE_Review corpus. Node 'ground', 'gnd', 'agnd', 'dgnd' all map to 0.
* EE_Review's own solvers skip this one: nonlinear or switched part: K1 (Magnetic coupling)
* EE_Review solve-dc: skip: nonlinear or switched part: K1 (Magnetic coupling)
* EE_Review solve-op: skip: nonlinear or switched part: K1 (Magnetic coupling)
* UNSUPPORTED: Xsw: subcircuit instance (Block (PWM-driven switch))
*
* MODEL DIODE: Is=1e-14 N=1  (diode)

Vin in 0 DC 150
L1 in sw 500u
L2 sec_a 0 50u
K1 L1 L2 0.98
Xsw sw 0 pwm 0 PWM_DRIVEN_SWITCH
Vpwm pwm 0 PULSE(0 10 0 1n 1n 2.25u 4.5u)
Dsnub sw snub_cap DIODE
Csnub snub_cap 0 10n
Rsnub snub_cap sw 10k
Dout sec_a out DIODE
Cout out 0 470u
Rload out 0 4.8

.end
