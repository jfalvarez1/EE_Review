* MOSFET Fundamentals - m06l01-5
* from lessons/module-06/lesson-01.html (build table 5)
* EE_Review corpus. Node 'ground', 'gnd', 'agnd', 'dgnd' all map to 0.
* EE_Review solve-dc: skip: nonlinear or switched part: M1 (Transistor (MOSFET))
* EE_Review solve-op: solved
*
* MODEL NMOS: Vth=0.7 Kp=0.00011 WL=10 K=0.0011 lambda=0.04  (nmos)

VDD vdd 0 DC 12
VIN in 0 SIN(0 100m 1k) AC 100m
R1 vdd gate 100k
R2 gate 0 50k
M1 drain gate source NMOS W=10u L=1u LAMBDA=0.04 VTO=0.7 KP=110u
RD vdd drain 2k
RS source 0 500
CIN in gate 1u

.end
