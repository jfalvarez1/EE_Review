* ADC Fundamentals - m17l02
* from lessons/module-17/lesson-02.html (build table 1)
* EE_Review corpus. Node 'ground', 'gnd', 'agnd', 'dgnd' all map to 0.
* EE_Review's own solvers skip this one: time-varying source, no single DC value: VSAMPLE
* EE_Review solve-dc: skip: nonlinear or switched part: M1 (Transistor (MOSFET))
* EE_Review solve-op: skip: time-varying source, no single DC value: VSAMPLE
*
* MODEL NMOS: Vth=0.7 Kp=0.00011 WL=10 K=0.0011 lambda=0.04  (nmos)

VIN in 0 DC 1.65 SIN(1.65 1.5 1k) AC 1.5
M1 in sample hold NMOS W=10u L=1u LAMBDA=0.04 VTO=0.7 KP=110u
CHOLD hold 0 100p
VSAMPLE sample 0 PULSE(0 5 0 1n 1n 5u 10u)
XU1 hold 0 out OPAMP
* fallback if X is unavailable: EU1 out 0 hold 0 100k
VCC vcc 0 DC 5
VEE vee 0 DC 0

.end
