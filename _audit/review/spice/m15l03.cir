* Battery Protection Circuits - m15l03
* from lessons/module-15/lesson-03.html (build table 1)
* EE_Review corpus. Node 'ground', 'gnd', 'agnd', 'dgnd' all map to 0.
* EE_Review's own solvers skip this one: nonlinear or switched part: Xprot (Block (protection IC))
* EE_Review solve-dc: skip: nonlinear or switched part: Xprot (Block (protection IC))
* EE_Review solve-op: skip: nonlinear or switched part: Xprot (Block (protection IC))
* UNSUPPORTED: Xprot: subcircuit instance (Block (protection IC))
*
* MODEL PMOS: Vth=0.7 Kp=0.00011 WL=10 K=0.0011 lambda=0.04  (pmos)

Vcell cell_pos 0 DC 3.7
Xprot cell_pos 0 gate_d gate_c cs PROTECTION_IC
Mdsg p_mid gate_d cell_pos PMOS W=10u L=1u LAMBDA=0.04 VTO=0.7 KP=110u
Mchg p_mid gate_c p_pos PMOS W=10u L=1u LAMBDA=0.04 VTO=0.7 KP=110u
Rsense p_pos cs 20m
Rload cs 0 1

.end
