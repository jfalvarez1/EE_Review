* DC-DC Converter Loop Compensation & Stability - m25l16
* from lessons/module-25/lesson-16.html (build table 1)
* EE_Review corpus. Node 'ground', 'gnd', 'agnd', 'dgnd' all map to 0.
* EE_Review solve-dc: skip: singular - no unique operating point (an amplifier with no feedback, or a floating section)
* EE_Review solve-op: skip: no semiconductors

Vfb fb 0 AC 1
R1 fb inv 10k
R3 fb node1 1k
C3 node1 inv 10n
R2 inv node2 100k
C2 node2 out 2.2n
C1 inv out 100p
Vref ref 0 DC 600m
XU1 ref inv out OPAMP
* fallback if X is unavailable: EU1 out 0 ref inv 100k

.end
