* RS-485 Differential Signaling - m20l05
* from lessons/module-20/lesson-05.html (build table 1)
* EE_Review corpus. Node 'ground', 'gnd', 'agnd', 'dgnd' all map to 0.
* EE_Review's own solvers skip this one: time-varying source, no single DC value: VIN
* EE_Review solve-dc: skip: time-varying source, no single DC value: VIN
* EE_Review solve-op: skip: time-varying source, no single DC value: VIN
* UNSUPPORTED: XTX: subcircuit instance (Block (RS-485 driver))
* UNSUPPORTED: XRX: subcircuit instance (Block (RS-485 receiver))

VCC vcc 0 DC 5
VIN txdata 0 PULSE(0 5 0 1n 1n 2.17u 4.34u)
VDE de 0 DC 5
XTX txdata de lineA_tx lineB_tx 0 vcc RS_485_DRIVER
RT lineA_rx lineB_rx 120
VRE re 0 DC 0
XRX lineA_rx lineB_rx re rxout 0 vcc RS_485_RECEIVER

.end
