* Monotonicity in Data Converters - m17l15
* from lessons/module-17/lesson-15.html (build table 1)
* EE_Review corpus. Node 'ground', 'gnd', 'agnd', 'dgnd' all map to 0.
* EE_Review's own solvers skip this one: nonlinear or switched part: S3 (SPDT Switch)
* EE_Review solve-dc: skip: nonlinear or switched part: S3 (SPDT Switch)
* EE_Review solve-op: skip: nonlinear or switched part: S3 (SPDT Switch)
* UNSUPPORTED: S3: subcircuit instance (SPDT Switch)
* UNSUPPORTED: S2: subcircuit instance (SPDT Switch)
* UNSUPPORTED: S1: subcircuit instance (SPDT Switch)
* UNSUPPORTED: S0: subcircuit instance (SPDT Switch)

VREF vref 0 DC 5
XS3 vref 0 b3_sw b3_in SPDT_SWITCH
XS2 vref 0 b2_sw b2_in SPDT_SWITCH
XS1 vref 0 b1_sw b1_in SPDT_SWITCH
XS0 vref 0 b0_sw b0_in SPDT_SWITCH
R3A b3_sw n3 2.02k
R3B n3 n2 1k
R2A b2_sw n2 2k
R2B n2 n1 1k
R1A b1_sw n1 2k
R1B n1 n0 1k
R0A b0_sw n0 2k
RT n0 0 2k
EBUF out 0 n3 0 1
VB3 b3_in 0 PULSE(0 5 0 1n 1n 5u 10u)
VB2 b2_in 0 PULSE(5 0 0 1n 1n 5u 10u)
VB1 b1_in 0 PULSE(5 0 0 1n 1n 5u 10u)
VB0 b0_in 0 PULSE(5 0 0 1n 1n 5u 10u)

.end
