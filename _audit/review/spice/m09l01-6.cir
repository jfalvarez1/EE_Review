* LC Oscillators - m09l01-6
* from lessons/module-09/lesson-01.html (build table 6)
* EE_Review corpus. Node 'ground', 'gnd', 'agnd', 'dgnd' all map to 0.
* EE_Review solve-dc: solved
* EE_Review solve-op: skip: no semiconductors

VCC vcc 0 DC 15
VEE vee 0 DC -15
XU1 pos neg out OPAMP
* fallback if X is unavailable: EU1 out 0 pos neg 100k
R3 neg 0 10k
R4 neg out 20k
R1 out n1 10k
C1 n1 pos 10n
R2 pos 0 10k
C2 pos 0 10n

.end
