* I2C Physical Layer & Analog Challenges - m20l01
* from lessons/module-20/lesson-01.html (build table 1)
* EE_Review corpus. Node 'ground', 'gnd', 'agnd', 'dgnd' all map to 0.
* EE_Review's own solvers skip this one: time-varying source, no single DC value: VSCL
* EE_Review solve-dc: skip: nonlinear or switched part: M_SCL (Transistor (MOSFET))
* EE_Review solve-op: skip: time-varying source, no single DC value: VSCL
*
* MODEL NMOS: Vth=0.7 Kp=0.00011 WL=10 K=0.0011 lambda=0.04  (nmos)

RPU_SCL vcc scl 4.7k
RPU_SDA vcc sda 4.7k
CBUS_SCL scl 0 100p
CBUS_SDA sda 0 100p
M_SCL scl scl_gate 0 NMOS W=10u L=1u LAMBDA=0.04 VTO=0.7 KP=110u
M_SDA sda sda_gate 0 NMOS W=10u L=1u LAMBDA=0.04 VTO=0.7 KP=110u
VSCL scl_gate 0 PULSE(0 3.3 0 1n 1n 625n 1.25u)
VSDA sda_gate 0 PULSE(0 3.3 0 1n 1n 1.25u 2.5u)
VCC vcc 0 DC 3.3

.end
