* Output Protection Circuits - m07l04
* from lessons/module-07/lesson-04.html (build table 1)
* EE_Review corpus. Node 'ground', 'gnd', 'agnd', 'dgnd' all map to 0.
* EE_Review solve-dc: skip: nonlinear or switched part: Q1 (Transistor (BJT))
* EE_Review solve-op: solved
*
* MODEL NPN: Is=1e-14 BF=100 BR=1 NF=1  (npn)

Q1 vin base out NPN
RSENSE out load 1
Q2 base out load NPN
VIN vin 0 DC 15
RBIAS vin base 1k
RLOAD load 0 10

.end
