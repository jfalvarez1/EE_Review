* The Differential Pair - m05l11-6
* from lessons/module-05/lesson-11.html (build table 6)
* EE_Review corpus. Node 'ground', 'gnd', 'agnd', 'dgnd' all map to 0.
* EE_Review solve-dc: skip: nonlinear or switched part: Q1 (Transistor (BJT))
* EE_Review solve-op: solved
*
* MODEL 2N3904: Is=6.734e-15 BF=416.4 BR=0.7371 NF=1  (npn)

VCC vcc 0 DC 12
VIN in 0 DC 2
Q1 vcc in e1 2N3904
Q2 vcc e1 out 2N3904
RL out 0 1k

.end
