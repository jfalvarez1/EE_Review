* Case Study: RF Interference Investigation - m23l10
* from lessons/module-23/lesson-10.html (build table 1)
* EE_Review corpus. Node 'ground', 'gnd', 'agnd', 'dgnd' all map to 0.
* EE_Review solve-dc: skip: nonlinear or switched part: D1 (Diode)
* EE_Review solve-op: solved
*
* MODEL DIODE: Is=1e-14 N=1  (diode)

Vrf rf 0 SIN(0 7m 150MEG) AC 7m
Ccouple rf in1 1p
Rs in1 in2 1k
D1 in2 vdd DIODE
D2 0 in2 DIODE
Vdd vdd 0 DC 5
Radc in2 0 10MEG
Cadc in2 0 10p

.end
