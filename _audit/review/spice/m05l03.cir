* BJT High-Frequency AC Model - m05l03
* from lessons/module-05/lesson-03.html (build table 1)
* EE_Review corpus. Node 'ground', 'gnd', 'agnd', 'dgnd' all map to 0.
* EE_Review solve-dc: skip: nonlinear or switched part: Q1 (Transistor (BJT))
* EE_Review solve-op: solved
*
* MODEL 2N3904: Is=6.734e-15 BF=416.4 BR=0.7371 NF=1  (npn)

VCC vcc 0 DC 12
VIN in 0 SIN(0 10m 1k) AC 10m
R1 vcc base 47k
R2 base 0 10k
RC vcc col 4.7k
RE emitter 0 1k
CE emitter 0 100u
CIN in base 1u
COUT col out 1u
RL out 0 10k
Q1 col base emitter 2N3904

.end
