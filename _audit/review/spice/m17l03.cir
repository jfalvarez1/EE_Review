* Sample and Hold Circuits - m17l03
* from lessons/module-17/lesson-03.html (build table 1)
* EE_Review corpus. Node 'ground', 'gnd', 'agnd', 'dgnd' all map to 0.
* EE_Review's own solvers skip this one: time-varying source, no single DC value: VCTRL
* EE_Review solve-dc: skip: nonlinear or switched part: M1 (Transistor (MOSFET))
* EE_Review solve-op: skip: time-varying source, no single DC value: VCTRL
*
* MODEL NMOS: Vth=0.7 Kp=0.00011 WL=10 K=0.0011 lambda=0.04  (nmos)

VIN in 0 DC 1.5
M1 in ctrl hold NMOS W=10u L=1u LAMBDA=0.04 VTO=0.7 KP=110u
CHOLD hold 0 100p
VCTRL ctrl 0 PULSE(5 0 0 1n 1n 4.5u 9u)
XU1 hold fb out OPAMP
* fallback if X is unavailable: EU1 out 0 hold fb 100k
R1 out fb 10k
R2 fb 0 10k
VCC vcc 0 DC 5
VEE vee 0 DC 0

.end
