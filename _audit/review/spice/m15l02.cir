* Cell Balancing Circuits - m15l02
* from lessons/module-15/lesson-02.html (build table 1)
* EE_Review corpus. Node 'ground', 'gnd', 'agnd', 'dgnd' all map to 0.
* EE_Review solve-dc: skip: nonlinear or switched part: Mbal1 (NMOS)
* EE_Review solve-op: solved
*
* MODEL NMOS: Vth=0.7 Kp=0.00011 WL=10 K=0.0011 lambda=0.04  (nmos)

Vcell1 cell1_int 0 DC 4.15
Rcell1 cell1_int cell1_pos 50m
Vcell2 cell2_int cell1_pos DC 4.1
Rcell2 cell2_int cell2_pos 50m
Vcell3 cell3_int cell2_pos DC 4.08
Rcell3 cell3_int cell3_pos 50m
Vcell4 cell4_int cell3_pos DC 4.05
Rcell4 cell4_int pack_pos 50m
Rbal1 cell1_pos bal1_r 10
Mbal1 bal1_r en1 0 NMOS W=10u L=1u LAMBDA=0.04 VTO=0.7 KP=110u
Ven1 en1 0 DC 5
Rbal2 cell2_pos bal2_r 10
Mbal2 bal2_r en2 cell1_pos NMOS W=10u L=1u LAMBDA=0.04 VTO=0.7 KP=110u
Ven2 en2 cell1_pos DC 0
Rbal3 cell3_pos bal3_r 10
Mbal3 bal3_r en3 cell2_pos NMOS W=10u L=1u LAMBDA=0.04 VTO=0.7 KP=110u
Ven3 en3 cell2_pos DC 0
Rbal4 pack_pos bal4_r 10
Mbal4 bal4_r en4 cell3_pos NMOS W=10u L=1u LAMBDA=0.04 VTO=0.7 KP=110u
Ven4 en4 cell3_pos DC 0

.end
