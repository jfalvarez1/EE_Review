* BLDC Motor Driver Design - m26l01
* from lessons/module-26/lesson-01.html (build table 1)
* EE_Review corpus. Node 'ground', 'gnd', 'agnd', 'dgnd' all map to 0.
* EE_Review's own solvers skip this one: time-varying source, no single DC value: VPWM_H
* EE_Review solve-dc: skip: time-varying source, no single DC value: VPWM_H
* EE_Review solve-op: skip: time-varying source, no single DC value: VPWM_H
*
* MODEL DIODE: Is=1e-14 N=1  (diode)
* MODEL NMOS: Vth=0.7 Kp=0.00011 WL=10 K=0.0011 lambda=0.04  (nmos)

VDC vdc 0 DC 48
VLOGIC vlogic 0 DC 12
VPWM_H pwm_h 0 PULSE(0 12 0 1n 1n 11u 24u)
VPWM_L pwm_l 0 PULSE(0 12 0 1n 1n 11u 24u)
Dboot vlogic vb DIODE
Cboot vb vs 1u
MHS vdc pwm_h_gate vs NMOS W=10u L=1u LAMBDA=0.04 VTO=0.7 KP=110u
Rg_hs hs_drv pwm_h_gate_in 10
EHS hs_drv vs pwm_h 0 1
Rhs_gd pwm_h_gate_in pwm_h_gate 1
MLS vs pwm_l_gate 0 NMOS W=10u L=1u LAMBDA=0.04 VTO=0.7 KP=110u
Rg_ls ls_drv pwm_l_gate_in 10
ELS ls_drv 0 pwm_l 0 1
Rls_gd pwm_l_gate_in pwm_l_gate 1
Lmotor vs vmotor_mid 100u
Rmotor vmotor_mid bemf 500m
VBEMF bemf 0 DC 18
Dhs_body vs vdc DIODE
Dls_body 0 vs DIODE

.end
