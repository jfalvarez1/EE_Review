* Debugging EMI/RFI Problems - m24l08
* from lessons/module-24/lesson-08.html (build table 1)
* EE_Review corpus. Node 'ground', 'gnd', 'agnd', 'dgnd' all map to 0.
* EE_Review's own solvers skip this one: time-varying source, no single DC value: Vnoise
* EE_Review solve-dc: skip: time-varying source, no single DC value: Vnoise
* EE_Review solve-op: skip: time-varying source, no single DC value: Vnoise

Vnoise in 0 PULSE(0 5 0 500p 500p 250n 500n)
Cx1 in n1 100n
L1 n1 n2 1m
L2 0 n3 1m
K1 L1 L2 0.99
Cy1 n2 0 4.7n
Cy2 n3 0 4.7n
Rgnd 0 0 1m
Cx2 n2 n3 100n
Rload n2 n3 100

.end
