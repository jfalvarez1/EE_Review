* Power Amplifiers (PA) - m21l03
* from lessons/module-21/lesson-03.html (build table 1)
* EE_Review corpus. Node 'ground', 'gnd', 'agnd', 'dgnd' all map to 0.
* EE_Review solve-dc: skip: nonlinear or switched part: M1 (Transistor (MOSFET))
* EE_Review solve-op: solved
*
* MODEL NMOS: Vth=0.7 Kp=0.00011 WL=10 K=0.0011 lambda=0.04  (nmos)

VDD vdd 0 DC 1.8
Vbias vb 0 DC 700m
Vin rfin 0 SIN(0 100m 2.4G) AC 100m
Cin rfin match1 5p
Lmatch match1 gate 2n
Cmatch gate match2 3p
Rmatch match2 0 50
Rbias gate vb 5k
Cbias gate 0 100p
Rstab gate rstab_out 10
Cstab rstab_out 0 10p
M1 drain gate source NMOS W=10u L=1u LAMBDA=0.04 VTO=0.7 KP=110u
Lsource source 0 100p
LRFC vdd drain 10n
Cbypass vdd drain 100p
Cout drain out1 2p
Lout out1 out2 1.5n
Cout2 out2 rfout 3p
Cshunt out2 0 1p
RL rfout 0 50

.end
