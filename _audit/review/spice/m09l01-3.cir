* LC Oscillators - m09l01-3
* from lessons/module-09/lesson-01.html (build table 3)
* EE_Review corpus. Node 'ground', 'gnd', 'agnd', 'dgnd' all map to 0.
* EE_Review solve-dc: skip: nonlinear or switched part: Q1 (Transistor (BJT))
* EE_Review solve-op: solved
*
* MODEL NPN: Is=1e-14 BF=100 BR=1 NF=1  (npn)

VCC vcc 0 DC 12
R1 vcc base 47k
R2 base 0 10k
RE emitter 0 1k
CE emitter 0 10n
L1 vcc collector 10u
C1 collector base 100p
C2 base 0 100p
Q1 collector base emitter NPN

.end
