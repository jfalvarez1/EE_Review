* Class AB Push-Pull Output Stages - m07l02
* from lessons/module-07/lesson-02.html (build table 1)
* EE_Review corpus. Node 'ground', 'gnd', 'agnd', 'dgnd' all map to 0.
* EE_Review solve-dc: skip: nonlinear or switched part: Q1 (Transistor (BJT))
* EE_Review solve-op: solved
*
* MODEL 1N4148: Is=2.52e-9 N=1.752  (diode)
* MODEL 2N3904: Is=6.734e-15 BF=416.4 BR=0.7371 NF=1  (npn)
* MODEL 2N3906: Is=1.41e-15 BF=180.7 BR=4.977 NF=1  (pnp)

Q1 vcc base1 out 2N3904
Q2 vee base2 out 2N3906
R1 vcc base1 1k
D1 base1 in 1N4148
D2 in base2 1N4148
R2 base2 vee 1k
VIN in 0 SIN(0 10 1k) AC 10
VCC vcc 0 DC 15
VEE vee 0 DC -15
RLOAD out 0 8

.end
