* RC Oscillators (Wien Bridge) - m09l02
* from lessons/module-09/lesson-02.html (build table 1)
* EE_Review corpus. Node 'ground', 'gnd', 'agnd', 'dgnd' all map to 0.
* EE_Review's own solvers skip this one: time-varying source, no single DC value: IIC
* EE_Review solve-dc: skip: time-varying source, no single DC value: IIC
* EE_Review solve-op: skip: time-varying source, no single DC value: IIC

XU1 inp inn out OPAMP
* fallback if X is unavailable: EU1 out 0 inp inn 100k
R1 out node1 10k
C1 node1 inp 10n
R2 inp 0 10k
C2 inp 0 10n
RF out inn 20k
RG inn 0 10k
VCC vcc 0 DC 15
VEE vee 0 DC -15
IIC 0 inp PULSE(0 1u 0 1n 1n 500u 1m)

.end
