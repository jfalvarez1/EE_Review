* Golden Rules and Basic Configurations - m01l02
* from lessons/module-01/lesson-02.html (build table 1)
* EE_Review corpus. Node 'ground', 'gnd', 'agnd', 'dgnd' all map to 0.
* EE_Review solve-dc: solved
* EE_Review solve-op: skip: no semiconductors

XU1 0 vm1 out1 OPAMP
* fallback if X is unavailable: EU1 out1 0 0 vm1 100k
R1inv in vm1 10k
RFinv vm1 out1 100k
VIN1 in 0 SIN(0 100m 1k) AC 100m
XU2 in2 vm2 out2 OPAMP
* fallback if X is unavailable: EU2 out2 0 in2 vm2 100k
R1non 0 vm2 10k
RFnon vm2 out2 100k
VIN2 in2 0 SIN(0 100m 1k) AC 100m

.end
