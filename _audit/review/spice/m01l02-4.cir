* Golden Rules and Basic Configurations - m01l02-4
* from lessons/module-01/lesson-02.html (build table 4)
* EE_Review corpus. Node 'ground', 'gnd', 'agnd', 'dgnd' all map to 0.
* EE_Review solve-dc: solved
* EE_Review solve-op: skip: no semiconductors

VCC vcc 0 DC 10
VEE vee 0 DC -10
VSIG sig 0 DC 3
RA sig vplus 10k
RB vplus 0 10k
XU1 vplus vminus out OPAMP
* fallback if X is unavailable: EU1 out 0 vplus vminus 100k
R1 vminus 0 2k
RF vminus out 8k

.end
