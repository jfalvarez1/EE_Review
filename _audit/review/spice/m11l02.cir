* Power vs Performance Trade-offs - m11l02
* from lessons/module-11/lesson-02.html (build table 1)
* EE_Review corpus. Node 'ground', 'gnd', 'agnd', 'dgnd' all map to 0.
* EE_Review's own solvers skip this one: nonlinear or switched part: U1 (Op-amp)
* EE_Review solve-dc: skip: nonlinear or switched part: U1 (Op-amp)
* EE_Review solve-op: skip: nonlinear or switched part: U1 (Op-amp)

XU1 in fb1 out1 OPAMP
* fallback if X is unavailable: EU1 out1 0 in fb1 100k
XU2 in fb2 out2 OPAMP
* fallback if X is unavailable: EU2 out2 0 in fb2 100k
R1 out1 fb1 10k
R2 fb1 0 10k
R3 out2 fb2 10k
R4 fb2 0 10k
VCC vcc 0 DC 3.3
VIN in 0 PULSE(0 100m 0 1n 1n 50u 100u)

.end
