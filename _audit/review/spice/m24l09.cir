* Debugging Signal Integrity Issues - m24l09
* from lessons/module-24/lesson-09.html (build table 1)
* EE_Review corpus. Node 'ground', 'gnd', 'agnd', 'dgnd' all map to 0.
* EE_Review's own solvers skip this one: time-varying source, no single DC value: Vdrv
* EE_Review solve-dc: skip: time-varying source, no single DC value: Vdrv
* EE_Review solve-op: skip: time-varying source, no single DC value: Vdrv

Vdrv drv 0 PULSE(0 3.3 0 10p 10p 5n 10n)
Rsrc drv src 25
Rload load 0 1MEG

.end
