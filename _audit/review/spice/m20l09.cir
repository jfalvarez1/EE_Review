* LVDS High-Speed Signaling - m20l09
* from lessons/module-20/lesson-09.html (build table 1)
* EE_Review corpus. Node 'ground', 'gnd', 'agnd', 'dgnd' all map to 0.
* EE_Review's own solvers skip this one: time-varying source, no single DC value: VIN
* EE_Review solve-dc: skip: time-varying source, no single DC value: VIN
* EE_Review solve-op: skip: time-varying source, no single DC value: VIN
* UNSUPPORTED: XTX: subcircuit instance (Block (LVDS driver))
* UNSUPPORTED: XRX: subcircuit instance (Block (LVDS receiver))

VCC vcc 0 DC 3.3
VIN data 0 PULSE(0 3.3 0 500f 500f 250p 500p)
XTX data dp_tx dn_tx vcc 0 LVDS_DRIVER
XRX dp_rx dn_rx out vcc 0 LVDS_RECEIVER

.end
