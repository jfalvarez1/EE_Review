* Laptop Power Architecture - m25l05
* from lessons/module-25/lesson-05.html (build table 1)
* EE_Review corpus. Node 'ground', 'gnd', 'agnd', 'dgnd' all map to 0.
* EE_Review's own solvers skip this one: time-varying source, no single DC value: VIN
* EE_Review solve-dc: skip: time-varying source, no single DC value: VIN
* EE_Review solve-op: skip: time-varying source, no single DC value: VIN
* UNSUPPORTED: Xbuck1: subcircuit instance (Block (buck regulator))
* UNSUPPORTED: Xbuck2: subcircuit instance (Block (buck regulator))
* UNSUPPORTED: Xbuck3: subcircuit instance (Block (buck regulator))
* UNSUPPORTED: Xvcore: subcircuit instance (Block (buck regulator))

VIN vin 0 PULSE(0 12 0 1n 1n 50m 100m)
Xbuck1 vin 0 v3p3 en1 pg1 buck_model VOUT_3_3 TSS_2m BUCK_REGULATOR
Ven1 en1 0 PULSE(0 3.3 0 1n 1n 500u 1m)
Xbuck2 vin 0 v1p8 pg1 pg2 buck_model VOUT_1_8 TSS_1_5m BUCK_REGULATOR
Xbuck3 vin 0 v1p2 pg2 pg3 buck_model VOUT_1_2 TSS_1m BUCK_REGULATOR
Xvcore vin 0 vcore pg3 pg4 buck_model VOUT_1_0 TSS_2m BUCK_REGULATOR
Rrst pg4 rst_ctrl 100k
Crst rst_ctrl 0 10n
RL1 v3p3 0 10
RL2 v1p8 0 3.6
RL3 v1p2 0 1.2
RLcore vcore 0 50m

.end
