* Headphone and Line Drivers - m16l02
* from lessons/module-16/lesson-02.html (build table 1)
* EE_Review corpus. Node 'ground', 'gnd', 'agnd', 'dgnd' all map to 0.
* EE_Review solve-dc: skip: nonlinear or switched part: Q1 (Transistor (BJT))
* EE_Review solve-op: solved
*
* MODEL 2N3904: Is=6.734e-15 BF=416.4 BR=0.7371 NF=1  (npn)
* MODEL 2N3906: Is=1.41e-15 BF=180.7 BR=4.977 NF=1  (pnp)

XU1 in fb node1 OPAMP
* fallback if X is unavailable: EU1 node1 0 in fb 100k
Q1 vcc node1 emN 2N3904
Q2 vee node1 emP 2N3906
Q3 vcc emN out 2N3904
Q4 vee emP out 2N3906
R1 emN emP 100
R2 node1 0 10k
RFB out fb 10k
RGND fb 0 10k
VCC vcc 0 DC 12
VEE vee 0 DC -12
VIN in 0 SIN(0 1 1k) AC 1
RLOAD out 0 32

.end
