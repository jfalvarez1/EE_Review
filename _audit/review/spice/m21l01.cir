* RF Matching Networks - m21l01
* from lessons/module-21/lesson-01.html (build table 1)
* EE_Review corpus. Node 'ground', 'gnd', 'agnd', 'dgnd' all map to 0.
* EE_Review solve-dc: solved
* EE_Review solve-op: skip: no semiconductors

V1 in 0 AC 1
R_src in node1 50
L1 node1 node2 26n
C1 node2 0 3.5p
R_load node2 0 150

.end
