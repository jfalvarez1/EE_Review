* Battery Charging Profiles - m15l04
* from lessons/module-15/lesson-04.html (build table 1)
* EE_Review corpus. Node 'ground', 'gnd', 'agnd', 'dgnd' all map to 0.
* EE_Review solve-dc: skip: singular - no unique operating point (an amplifier with no feedback, or a floating section)
* EE_Review solve-op: skip: no semiconductors

Vin in 0 DC 5
Icharge in bat_term DC 1
Rbat_int bat_term bat 50m
Cbat bat 0 10k

.end
