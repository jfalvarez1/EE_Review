* Analog Multiplexers - m08l06
* from lessons/module-08/lesson-06.html (build table 1)
* EE_Review corpus. Node 'ground', 'gnd', 'agnd', 'dgnd' all map to 0.
* EE_Review's own solvers skip this one: nonlinear or switched part: Xmux (Block (4:1 multiplexer))
* EE_Review solve-dc: skip: nonlinear or switched part: Xmux (Block (4:1 multiplexer))
* EE_Review solve-op: skip: nonlinear or switched part: Xmux (Block (4:1 multiplexer))
* UNSUPPORTED: Xmux: subcircuit instance (Block (4:1 multiplexer))

Vin0 ch0 0 DC 1
Vin1 ch1 0 DC 2
Vin2 ch2 0 DC 3
Vin3 ch3 0 DC 4
Xmux out ch0 ch1 ch2 ch3 a0 a1 vdd vss 4_1_MULTIPLEXER
Vdd vdd 0 DC 5
Vss vss 0 DC -5
Va0 a0 0 PULSE(0 5 0 1n 1n 5u 10u)
Va1 a1 0 PULSE(0 5 0 1n 1n 10u 20u)
XUbuf out_buf out 0 OPAMP
* fallback if X is unavailable: EUbuf 0 0 out_buf out 100k
Cload out_buf 0 100p

.end
