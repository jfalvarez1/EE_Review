* Oscilloscope Techniques for Analog Debug - m24l11
* from lessons/module-24/lesson-11.html (build table 1)
* EE_Review corpus. Node 'ground', 'gnd', 'agnd', 'dgnd' all map to 0.
* EE_Review's own solvers skip this one: time-varying source, no single DC value: VPULSE
* EE_Review solve-dc: skip: time-varying source, no single DC value: VPULSE
* EE_Review solve-op: skip: time-varying source, no single DC value: VPULSE

VPULSE sig 0 PULSE(0 1 0 100p 100p 50n 100n)
R_PROBE sig scope 9MEG
C_TIP sig scope 1.67p
R_INPUT scope gnd_ref 1MEG
C_INPUT scope gnd_ref 15p
L_GND gnd_ref 0 100n

.end
