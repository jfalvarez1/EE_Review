* Microphone Preamps - m16l03
* from lessons/module-16/lesson-03.html (build table 1)
* EE_Review corpus. Node 'ground', 'gnd', 'agnd', 'dgnd' all map to 0.
* EE_Review solve-dc: skip: singular - no unique operating point (an amplifier with no feedback, or a floating section)
* EE_Review solve-op: skip: no semiconductors

XU1 inP 0 bufP OPAMP
* fallback if X is unavailable: EU1 bufP 0 inP 0 100k
XU2 inN 0 bufN OPAMP
* fallback if X is unavailable: EU2 bufN 0 inN 0 100k
RGAIN bufP bufN 100
R1 bufP diff_in 10k
R2 bufN diff_neg 10k
R3 diff_in 0 10k
R4 diff_neg out 10k
XU3 diff_in diff_neg out OPAMP
* fallback if X is unavailable: EU3 out 0 diff_in diff_neg 100k
VCC vcc 0 DC 15
VEE vee 0 DC -15
VINP inP 0 SIN(0 1m 1k) AC 1m
VINN inN 0 SIN(0 -1m 1k) AC 1m
VCM inP 0 SIN(0 100m 60) AC 100m
VCM2 inN 0 SIN(0 100m 60) AC 100m

.end
