* Cost vs Performance Trade-offs - m11l03
* from lessons/module-11/lesson-03.html (build table 1)
* EE_Review corpus. Node 'ground', 'gnd', 'agnd', 'dgnd' all map to 0.
* EE_Review solve-dc: solved
* EE_Review solve-op: skip: no semiconductors

RSENSOR sensor 0 1.1k
RREF vref sensor 1k
VREF vref 0 DC 2.5

.end
