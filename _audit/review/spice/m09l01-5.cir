* LC Oscillators - m09l01-5
* from lessons/module-09/lesson-01.html (build table 5)
* EE_Review corpus. Node 'ground', 'gnd', 'agnd', 'dgnd' all map to 0.
* EE_Review solve-dc: solved
* EE_Review solve-op: skip: no semiconductors

VCC vcc 0 DC 12
VEE vee 0 DC -12
XU1 0 inv out OPAMP
* fallback if X is unavailable: EU1 out 0 0 inv 100k
RF inv out 29k
RIN in inv 1k
R1 out n1 10k
C1 n1 0 10n
R2 n1 n2 10k
C2 n2 0 10n
R3 n2 in 10k
C3 in 0 10n

.end
