* Precision Analog Techniques - m08l03
* from lessons/module-08/lesson-03.html (build table 1)
* EE_Review corpus. Node 'ground', 'gnd', 'agnd', 'dgnd' all map to 0.
* EE_Review's own solvers skip this one: time-varying source, no single DC value: VCLK
* EE_Review solve-dc: skip: time-varying source, no single DC value: VCLK
* EE_Review solve-op: skip: time-varying source, no single DC value: VCLK
* UNSUPPORTED: SW_MOD: subcircuit instance (DPDT Switch)
* UNSUPPORTED: SW_DEMOD: subcircuit instance (DPDT Switch)

VIN input 0 DC 10m
VCLK clk 0 PULSE(0 5 0 1n 1n 25u 50u)
XSW_MOD 0 mod_p mod_n clk DPDT_SWITCH_ELECTRICALLY_DRIVEN_MDASH_THE_MODULATOR
VOFFSET mod_p amp_p DC 100u
E_AMP amp_out 0 amp_p mod_n 100
E_AMP_N amp_out_n 0 amp_p mod_n -100
XSW_DEMOD amp_out amp_out_n demod demod_n clk DPDT_SWITCH_ELECTRICALLY_DRIVEN_MDASH_THE_DEMODULATOR
R_LPF demod output 10k
C_LPF output 0 100n

.end
