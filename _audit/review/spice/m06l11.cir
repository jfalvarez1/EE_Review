* MOSFET as a Switch - m06l11
* from lessons/module-06/lesson-11.html (build table 1)
* EE_Review corpus. Node 'ground', 'gnd', 'agnd', 'dgnd' all map to 0.
* EE_Review's own solvers skip this one: time-varying source, no single DC value: VIN
* EE_Review solve-dc: skip: time-varying source, no single DC value: VIN
* EE_Review solve-op: skip: time-varying source, no single DC value: VIN
*
* MODEL NMOS: Vth=0.7 Kp=0.00011 WL=10 K=0.0011 lambda=0.04  (nmos)

VCC 1 0 DC 12
VIN 3 0 PULSE(0 10 0 1n 1n 2.5u 5u)
RG 3 2 10
M1 1 2 4 NMOS W=10u L=1u LAMBDA=0.04 VTO=0.7 KP=110u
RL 4 0 10

.end
