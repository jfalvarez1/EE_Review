* DC Errors: Vos, Ib, and Ios - m01l05
* from lessons/module-01/lesson-05.html (build table 1)
* EE_Review corpus. Node 'ground', 'gnd', 'agnd', 'dgnd' all map to 0.
* EE_Review's own solvers skip this one: nonlinear or switched part: U1 (Op-amp)
* EE_Review solve-dc: skip: nonlinear or switched part: U1 (Op-amp)
* EE_Review solve-op: skip: nonlinear or switched part: U1 (Op-amp)

XU1 0 inv out OPAMP
* fallback if X is unavailable: EU1 out 0 0 inv 100k
R1 in inv 10k
RF inv out 100k
RSRC src in 10k
VIN src 0 DC 0

.end
