* Class A Output Stages - m07l01
* from lessons/module-07/lesson-01.html (build table 1)
* EE_Review corpus. Node 'ground', 'gnd', 'agnd', 'dgnd' all map to 0.
* EE_Review solve-dc: skip: nonlinear or switched part: Q1 (Transistor (BJT))
* EE_Review solve-op: solved
*
* MODEL NPN: Is=1e-14 BF=100 BR=1 NF=1  (npn)

Q1 vcc in out NPN
IBIAS out 0 DC 100m
VCC vcc 0 DC 12
VIN in 0 DC 6 SIN(6 3 1k) AC 3
RLOAD out 0 120

.end
