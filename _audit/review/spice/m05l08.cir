* Common-Base Amplifier - m05l08
* from lessons/module-05/lesson-08.html (build table 1)
* EE_Review corpus. Node 'ground', 'gnd', 'agnd', 'dgnd' all map to 0.
* EE_Review solve-dc: skip: nonlinear or switched part: Q1 (Transistor (BJT))
* EE_Review solve-op: solved
*
* MODEL 2N3904: Is=6.734e-15 BF=416.4 BR=0.7371 NF=1  (npn)

VCC 1 0 DC 12
VIN 5 0 SIN(0 10m 1MEG) AC 10m
R1 1 2 22k
R2 2 0 4.7k
Q1 3 2 4 2N3904
RC 1 3 2.2k
RE 4 0 1k
CB 2 0 100n
CIN 5 4 100n
COUT 3 6 100n
RL 6 0 10k

.end
