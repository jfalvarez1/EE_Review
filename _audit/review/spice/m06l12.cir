* MOSFET Switching - m06l12
* from lessons/module-06/lesson-12.html (build table 1)
* EE_Review corpus. Node 'ground', 'gnd', 'agnd', 'dgnd' all map to 0.
* EE_Review's own solvers skip this one: nonlinear or switched part: M1 (Transistor (MOSFET, switching — low Rds(on)))
* EE_Review solve-dc: skip: nonlinear or switched part: M1 (Transistor (MOSFET, switching — low Rds(on)))
* EE_Review solve-op: skip: nonlinear or switched part: M1 (Transistor (MOSFET, switching — low Rds(on)))
*
* MODEL NMOS: Vth=0.7 Kp=0.00011 WL=10 K=0.0011 lambda=0.04  (nmos)

M1 drain gate 0 NMOS W=10u L=1u LAMBDA=0.04 VTO=0.7 KP=110u
VGATE gate_drv 0 PULSE(0 10 0 1n 1n 2.5u 5u)
RGATE gate_drv gate 10
VDD vdd 0 DC 12
RLOAD vdd drain 10

.end
