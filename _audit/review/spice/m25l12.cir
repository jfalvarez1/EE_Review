* Why 4-20mA Current Loops? - m25l12
* from lessons/module-25/lesson-12.html (build table 1)
* EE_Review corpus. Node 'ground', 'gnd', 'agnd', 'dgnd' all map to 0.
* EE_Review's own solvers skip this one: nonlinear or switched part: Xtr (Block (XTR117))
* EE_Review solve-dc: skip: nonlinear or switched part: Xtr (Block (XTR117))
* EE_Review solve-op: skip: nonlinear or switched part: Xtr (Block (XTR117))
* UNSUPPORTED: Xtr: subcircuit instance (Block (XTR117))

Vloop LOOP_ 0 DC 24
Rsense LOOP_ RX 250
Vin INPUT 0 DC 500m
Xtr INPUT RX 0 XTR117

.end
