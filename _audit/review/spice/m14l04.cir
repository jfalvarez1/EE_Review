* Boost Converter Design - m14l04
* from lessons/module-14/lesson-04.html (build table 1)
* EE_Review corpus. Node 'ground', 'gnd', 'agnd', 'dgnd' all map to 0.
* EE_Review's own solvers skip this one: nonlinear or switched part: Xsw (Block (ideal switch))
* EE_Review solve-dc: skip: nonlinear or switched part: Xsw (Block (ideal switch))
* EE_Review solve-op: skip: nonlinear or switched part: Xsw (Block (ideal switch))
* UNSUPPORTED: Xsw: subcircuit instance (Block (ideal switch))
*
* MODEL SCHOTTKY: Is=0.0000317 N=1.37  (diode)

Vin in 0 DC 3.7
L1 in sw 22u
Xsw sw 0 pwm 0 IDEAL_SWITCH
Vpwm pwm 0 PULSE(0 5 0 1n 1n 700n 1.4u)
D1 sw out SCHOTTKY
Cout out 0 47u
Rload out 0 24

.end
