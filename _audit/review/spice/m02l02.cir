* Instrumentation Amplifiers - m02l02
* from lessons/module-02/lesson-02.html (build table 1)
* EE_Review corpus. Node 'ground', 'gnd', 'agnd', 'dgnd' all map to 0.
* EE_Review solve-dc: solved
* EE_Review solve-op: skip: no semiconductors

XU1 vp n1 out1 OPAMP
* fallback if X is unavailable: EU1 out1 0 vp n1 100k
XU2 vm n2 out2 OPAMP
* fallback if X is unavailable: EU2 out2 0 vm n2 100k
R1 n1 n2 500
R2 out1 n1 25k
R3 out2 n2 25k
XU3 n3 n4 vout OPAMP
* fallback if X is unavailable: EU3 vout 0 n3 n4 100k
R4 out2 n4 10k
R5 n4 vout 10k
R6 out1 n3 10k
R7 n3 vref 10k
VIN_P vp 0 DC 10m
VIN_M vm 0 DC -10m
VREF vref 0 DC 2.5

.end
