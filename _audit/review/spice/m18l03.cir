* Scenario: Precision RTD Temperature Measurement - m18l03
* from lessons/module-18/lesson-03.html (build table 1)
* EE_Review corpus. Node 'ground', 'gnd', 'agnd', 'dgnd' all map to 0.
* EE_Review solve-dc: solved
* EE_Review solve-op: skip: no semiconductors

IEX 0 rtd_hi DC 1m
RRTD rtd_hi rtd_lo 109.63
RLEAD1 rtd_hi sense_hi 1
RLEAD2 rtd_lo sense_lo 1
EAMP amp_out 0 sense_hi sense_lo 10
RFILT amp_out adc_in 1k
CFILT adc_in 0 100n
RREF rtd_lo 0 1k

.end
