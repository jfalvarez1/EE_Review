* Decoupling & Bypass Strategy - m14l01
* from lessons/module-14/lesson-01.html (build table 1)
* EE_Review corpus. Node 'ground', 'gnd', 'agnd', 'dgnd' all map to 0.
* EE_Review solve-dc: solved
* EE_Review solve-op: skip: no semiconductors

C1 vcc 0 10u
RC1 vcc c1_mid 10m
LC1 c1_mid 0 1n
C2 vcc 0 100n
RC2 vcc c2_mid 5m
LC2 c2_mid 0 500p
C3 vcc 0 10n
RC3 vcc c3_mid 5m
LC3 c3_mid 0 300p
VAC vcc 0 AC 1

.end
