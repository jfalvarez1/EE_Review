* EE_Review: protocol-open-drain-fine
* Assumed lumped educational model, NOT a specific IC or measured board.
VDD vdd 0 3.3
RP vdd bus 2.2k
CB bus 0 100p
VA ea 0 PWL(0 0 2u 0 2.01u 1 6u 1 6.01u 0)
VB eb 0 PWL(0 0 4u 0 4.01u 1 8u 1 8.01u 0)
RA bus aa 22
SA aa 0 ea 0 EN
RB bus bb 22
SB bb 0 eb 0 EN
.model EN SW(Ron=0.01 Roff=1T Vt=0.5 Vh=0)
.tran 0 10u 0 2.5e-10
.save V(bus) I(VDD)
.options plotwinsize=0 numdgt=15 reltol=1e-6 vntol=1e-8 abstol=1e-11
.end
