* EE_Review illustrative PDN experiment: pdn-bank-c
* Explicit lumped assumptions; no extracted PCB or vendor capacitor model.
VAC port 0 AC 1
R1 port r1 0.01
L1 r1 c1 1n Rser=0
C1 c1 0 3.7e-06 Rser=0
R2 port r2 0.01
L2 r2 c2 1n Rser=0
C2 c2 0 3.7e-06 Rser=0
R3 port r3 0.01
L3 r3 c3 1n Rser=0
C3 c3 0 3.7e-06 Rser=0
.ac dec 200 1k 100meg
.save V(port) I(VAC)
.options plotwinsize=0 numdgt=15 reltol=1e-6 vntol=1e-8 abstol=1e-10
.end
