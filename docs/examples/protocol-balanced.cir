* EE_Review: protocol-balanced
* Assumed lumped educational model, NOT a specific IC or measured board.
VH high 0 3.3
VEA ea 0 PWL(0 1 6u 1 6.01u 0)
VEB eb 0 PWL(0 0 2u 0 2.01u 1 8u 1 8.01u 0)
SA high ah ea 0 EN
RA ah bus 22
RB bus bl 22
SB bl 0 eb 0 EN
CB bus 0 100p
RLEAK bus 0 1meg
.model EN SW(Ron=0.01 Roff=1T Vt=0.5 Vh=0)
.tran 0 10u 0 5e-10
.save V(bus) I(RA) V(ea) V(eb)
.options plotwinsize=0 numdgt=15 reltol=1e-6 vntol=1e-8 abstol=1e-11
.end
