* EE_Review: protocol-released-fine
* Assumed lumped educational model, NOT a specific IC or measured board.
VDD vdd 0 3.3
VE e 0 PWL(0 1 2u 1 2.01u 0)
.model EN SW(Ron=0.01 Roff=1T Vt=0.5 Vh=0)
S0 vdd a0 e 0 EN
RD0 a0 z0 22
C0 z0 0 100p
R0 z0 0 1T
S1 vdd a1 e 0 EN
RD1 a1 z1 22
C1 z1 0 100p
R1 z1 0 100k
S2 vdd a2 e 0 EN
RD2 a2 z2 22
C2 z2 0 100p
R2 z2 0 10k
.tran 0 30u 0 2.5e-09
.save V(z0) V(z1) V(z2)
.options plotwinsize=0 numdgt=15 reltol=1e-6 vntol=1e-8 abstol=1e-11
.end
