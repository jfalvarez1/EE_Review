* EE_Review illustrative PDN experiment: pdn-path-30n-fine
* Explicit lumped assumptions; no extracted PCB or vendor capacitor model.
VREG src 0 1
Rreg src supply 0.005
Rb supply rb 0.01
Lb rb cb 1n Rser=0
Cb cb 0 100u Rser=0
Rpath supply rp 0.005
Lpath rp load 3e-08 Rser=0
Rc load rc 0.01
Lc rc cc 1n Rser=0
Clocal cc 0 1e-05 Rser=0
* Raised-cosine 100ns edges: continuous current and derivative, no artificial voltage jumps.
BILOAD load 0 I=4*(if(time<2u,0,if(time<2.1u,(1-cos(pi*(time-2u)/100n))/2,1))-if(time<12u,0,if(time<12.1u,(1-cos(pi*(time-12u)/100n))/2,1)))
.tran 0 30u 0 2.5e-09
.save V(load) V(supply) I(BILOAD)
.options plotwinsize=0 numdgt=15 reltol=1e-6 vntol=1e-8 abstol=1e-10
.end
