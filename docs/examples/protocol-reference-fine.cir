* EE_Review: protocol-reference-fine
* Assumed lumped educational model, NOT a specific IC or measured board.
VPIN pin 0 PWL(0 3.3 50n 3.3 52n 0)
VREF ref 0 PWL(0 0 60n 0 65n 1 85n 1 90n 0)
BMEAS measured 0 V=V(pin)-V(ref)
.tran 0 180n 0 5e-11
.save V(pin) V(ref) V(measured)
.options plotwinsize=0 numdgt=15 reltol=1e-6 vntol=1e-8 abstol=1e-11
.end
