* Two-phase inverse-coupled magnetics fixture, not a closed-loop regulator.
* LTspice: open this file, run, plot I(L1), -I(L2), I(L1)-I(L2).
* Ideal voltage sources prescribe SW1, SW2 and VOUT; they can absorb energy.
* Pulse width compensates the 1 ns edges to preserve volt-second balance.
* Reversing L2's node order gives inverse coupling for currents SW -> OUT.
.param VIN=12 VOUT=1.2 FS=600k LTR=75n
.param D={VOUT/VIN} T={1/FS} LS={LTR/(1-KC)}
.step param KC list 0 0.5 0.7
VSW1 sw1 0 PULSE(0 {VIN} 0 1n 1n {D*T-1n} {T})
VSW2 sw2 0 PULSE(0 {VIN} {T/2} 1n 1n {D*T-1n} {T})
VCLAMP out 0 {VOUT}
L1 sw1 out {LS} Rser=0 IC=20
L2 out sw2 {LS} Rser=0 IC=-20
KPAIR L1 L2 {KC}
.tran 0 {20*T} {18*T} {T/1000} uic
.meas tran phase_pp PP I(L1) FROM {18*T} TO {20*T}
.meas tran sum_pp PP (I(L1)-I(L2)) FROM {18*T} TO {20*T}
.end
