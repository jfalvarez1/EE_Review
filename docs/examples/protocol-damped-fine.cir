* EE_Review: protocol-damped-fine
* Assumed lumped educational model, NOT a specific IC or measured board.
VIN src 0 PWL(0 3.3 50n 3.3 52n 0)
RS src n1 63.2455532034
LP n1 pin 100n Rser=0
CP pin 0 100p Rser=0
.tran 0 180n 0 5e-11
.save V(pin) V(src) I(LP)
.options plotwinsize=0 numdgt=15 reltol=1e-6 vntol=1e-8 abstol=1e-11
.end
